// VerilogA for a-GIZO TFT ANN static model -- 2-HIDDEN-LAYER variant.
// 4 inputs -> 32 tanh -> 16 tanh -> 1 linear output.
//
// Same conventions as tft_ann_static.va (single hidden layer): [0,1] input
// scaling, log10(|ID|) standardized target, linear output layer. Trained
// with the same monotonicity penalty + L-balanced loss as the 1-layer
// model, on cleaned_output_meas/merged_output_dataset.csv.
//
// Auto-generated by scripts/export_verilog_a_deep.py from
// trained_ANN/deep/weights.json. Do not hand-edit -- regenerate instead.

`include "constants.h"
`include "disciplines.h"

module tft_ann_static_deep(D, G, S);
inout G, D, S;
electrical D, G, S;

parameter integer NI = 4;
parameter integer NH1 = 32;
parameter integer NH2 = 16;

parameter real w = 40e-6 from [5e-6:160e-6];
parameter real l = 10e-6 from [5e-6:20e-6];

real w1[0:(NI*NH1)-1]; real b1[0:NH1-1]; real y1[0:NH1-1]; real v1[0:NH1-1];
real w2[0:(NH1*NH2)-1]; real b2[0:NH2-1]; real y2[0:NH2-1]; real v2[0:NH2-1];
real wo[0:NH2-1]; real bo;

real vg_s, vd_s, width_s, length_s;
real log_id, id;
integer i, j;

real vg_lo, vg_hi, vd_lo, vd_hi, w_lo, w_hi, l_lo, l_hi;
real y_mean, y_std;

analog begin
	@(initial_step or initial_step("static")) begin

	vg_lo = -5.000000; vg_hi = 5.000000;
	vd_lo = 0.000000; vd_hi = 5.000000;
	w_lo  = 5.0e-6; w_hi  = 160.0e-6;
	l_lo  = 5.0e-6; l_hi  = 20.0e-6;
	y_mean = -8.520563;
	y_std  = 3.184171;

	// layer 1 weights: w1[NI*i + k], k in {0:VG, 1:VD, 2:W, 3:L}
	w1[0] = 0.489155; 	 w1[1] = 0.973930; 	 w1[2] = 0.188468; 	 w1[3] = 0.390691;
	w1[4] = -1.213416; 	 w1[5] = 0.051716; 	 w1[6] = -0.263094; 	 w1[7] = 0.004503;
	w1[8] = 0.399144; 	 w1[9] = -4.443088; 	 w1[10] = -0.019902; 	 w1[11] = 0.107949;
	w1[12] = 3.097643; 	 w1[13] = -0.141100; 	 w1[14] = -0.175611; 	 w1[15] = -0.162886;
	w1[16] = 0.946950; 	 w1[17] = 0.073139; 	 w1[18] = -0.112898; 	 w1[19] = 0.367862;
	w1[20] = -0.744254; 	 w1[21] = -0.115568; 	 w1[22] = -0.138068; 	 w1[23] = 0.360483;
	w1[24] = -1.583334; 	 w1[25] = -0.029043; 	 w1[26] = 0.020400; 	 w1[27] = -0.121902;
	w1[28] = -0.684513; 	 w1[29] = 0.003283; 	 w1[30] = 3.729250; 	 w1[31] = -2.785446;
	w1[32] = 1.081669; 	 w1[33] = 0.033492; 	 w1[34] = -0.336108; 	 w1[35] = 0.424874;
	w1[36] = 0.711425; 	 w1[37] = 0.406471; 	 w1[38] = 0.230302; 	 w1[39] = 0.053443;
	w1[40] = 1.324099; 	 w1[41] = -0.331033; 	 w1[42] = -0.147411; 	 w1[43] = 0.292915;
	w1[44] = 0.546763; 	 w1[45] = -0.282531; 	 w1[46] = 0.598534; 	 w1[47] = 0.434796;
	w1[48] = 0.313749; 	 w1[49] = 0.004218; 	 w1[50] = -4.996068; 	 w1[51] = 1.914150;
	w1[52] = -0.879493; 	 w1[53] = 0.669350; 	 w1[54] = 0.105767; 	 w1[55] = 0.172122;
	w1[56] = 0.337918; 	 w1[57] = 0.006678; 	 w1[58] = 0.405560; 	 w1[59] = -0.053739;
	w1[60] = 0.102990; 	 w1[61] = -25.760262; 	 w1[62] = 0.075716; 	 w1[63] = 0.023758;
	w1[64] = 0.318733; 	 w1[65] = 0.086756; 	 w1[66] = 0.664442; 	 w1[67] = -4.413779;
	w1[68] = -0.545077; 	 w1[69] = -0.274910; 	 w1[70] = 0.061456; 	 w1[71] = 0.029132;
	w1[72] = 1.125248; 	 w1[73] = -0.071040; 	 w1[74] = -1.973062; 	 w1[75] = -5.072545;
	w1[76] = -1.246557; 	 w1[77] = -0.160224; 	 w1[78] = -0.146388; 	 w1[79] = -0.043302;
	w1[80] = -1.470429; 	 w1[81] = -0.179616; 	 w1[82] = 0.386832; 	 w1[83] = -0.177040;
	w1[84] = 1.010652; 	 w1[85] = 0.184310; 	 w1[86] = 0.222876; 	 w1[87] = -0.317393;
	w1[88] = -1.261151; 	 w1[89] = 0.052041; 	 w1[90] = -0.013068; 	 w1[91] = -0.303475;
	w1[92] = 0.453865; 	 w1[93] = 0.350297; 	 w1[94] = 0.124348; 	 w1[95] = -0.025576;
	w1[96] = 0.648999; 	 w1[97] = 0.039723; 	 w1[98] = -0.172135; 	 w1[99] = -0.874843;
	w1[100] = -0.648376; 	 w1[101] = 0.260334; 	 w1[102] = 0.366178; 	 w1[103] = -0.007695;
	w1[104] = -0.876389; 	 w1[105] = -0.095522; 	 w1[106] = -0.457587; 	 w1[107] = -0.570804;
	w1[108] = -2.145184; 	 w1[109] = 0.004233; 	 w1[110] = 5.709260; 	 w1[111] = 3.729073;
	w1[112] = 1.650931; 	 w1[113] = -0.265010; 	 w1[114] = -0.116123; 	 w1[115] = 0.023128;
	w1[116] = 2.114063; 	 w1[117] = -0.085739; 	 w1[118] = 0.128350; 	 w1[119] = -0.025990;
	w1[120] = 3.053837; 	 w1[121] = 0.095287; 	 w1[122] = 0.218960; 	 w1[123] = -0.197283;
	w1[124] = 0.208949; 	 w1[125] = -0.008235; 	 w1[126] = -0.474339; 	 w1[127] = -6.954501;
	// layer 1 bias
	b1[0] = 0.563700;
	b1[1] = 0.385136;
	b1[2] = -0.604453;
	b1[3] = -0.871648;
	b1[4] = -0.704905;
	b1[5] = 0.733962;
	b1[6] = 0.484576;
	b1[7] = -1.361373;
	b1[8] = -0.806255;
	b1[9] = -0.678429;
	b1[10] = -0.651912;
	b1[11] = -0.632606;
	b1[12] = -0.343287;
	b1[13] = 0.142369;
	b1[14] = 0.152639;
	b1[15] = -0.444058;
	b1[16] = -0.759782;
	b1[17] = 0.171465;
	b1[18] = 0.377838;
	b1[19] = 0.635626;
	b1[20] = 0.784596;
	b1[21] = -0.743621;
	b1[22] = 0.571653;
	b1[23] = -0.225234;
	b1[24] = 0.097915;
	b1[25] = 0.277337;
	b1[26] = 1.123474;
	b1[27] = -1.699205;
	b1[28] = -0.192815;
	b1[29] = -0.403361;
	b1[30] = -0.958974;
	b1[31] = 0.111784;

	// layer 2 weights: w2[NH1*i + k]
	w2[0] = 0.532267; 	 w2[1] = 0.003397; 	 w2[2] = 0.055603; 	 w2[3] = -0.461591; 	 w2[4] = -0.124538; 	 w2[5] = 0.267358; 	 w2[6] = -0.031885; 	 w2[7] = 0.126987; 	 w2[8] = -0.140142; 	 w2[9] = -0.482824; 	 w2[10] = -0.214335; 	 w2[11] = -0.047892; 	 w2[12] = -0.127188; 	 w2[13] = 0.056478; 	 w2[14] = 0.273461; 	 w2[15] = -0.240251; 	 w2[16] = -0.279261; 	 w2[17] = -0.036033; 	 w2[18] = 0.098669; 	 w2[19] = -0.078410; 	 w2[20] = 0.338413; 	 w2[21] = 0.063184; 	 w2[22] = 0.077756; 	 w2[23] = 0.030734; 	 w2[24] = -0.023782; 	 w2[25] = -0.082329; 	 w2[26] = 0.599347; 	 w2[27] = -0.994188; 	 w2[28] = 0.046009; 	 w2[29] = 0.115286; 	 w2[30] = 0.154290; 	 w2[31] = -0.306457;
	w2[32] = 0.379405; 	 w2[33] = 0.231843; 	 w2[34] = 0.447823; 	 w2[35] = -0.408439; 	 w2[36] = -0.166371; 	 w2[37] = 0.641330; 	 w2[38] = 0.219686; 	 w2[39] = -0.343732; 	 w2[40] = -0.211880; 	 w2[41] = -0.230118; 	 w2[42] = -0.149769; 	 w2[43] = -0.065510; 	 w2[44] = 0.336822; 	 w2[45] = 0.121062; 	 w2[46] = 0.214365; 	 w2[47] = -0.346814; 	 w2[48] = -0.536465; 	 w2[49] = -0.156374; 	 w2[50] = 0.365440; 	 w2[51] = 0.208579; 	 w2[52] = 0.012371; 	 w2[53] = -0.365195; 	 w2[54] = 0.183527; 	 w2[55] = 0.313311; 	 w2[56] = -0.239014; 	 w2[57] = 0.016356; 	 w2[58] = 0.773058; 	 w2[59] = 0.478281; 	 w2[60] = -0.271077; 	 w2[61] = 0.103479; 	 w2[62] = 0.060671; 	 w2[63] = -0.121533;
	w2[64] = -0.047792; 	 w2[65] = -0.591728; 	 w2[66] = 0.089046; 	 w2[67] = 0.876157; 	 w2[68] = 0.680588; 	 w2[69] = -0.730789; 	 w2[70] = -0.707075; 	 w2[71] = 0.706061; 	 w2[72] = 0.862750; 	 w2[73] = 0.720040; 	 w2[74] = 1.122934; 	 w2[75] = 0.667764; 	 w2[76] = -0.100353; 	 w2[77] = -0.499272; 	 w2[78] = -0.104804; 	 w2[79] = -1.130242; 	 w2[80] = 0.710169; 	 w2[81] = -0.363320; 	 w2[82] = 0.430024; 	 w2[83] = -0.766011; 	 w2[84] = -0.961710; 	 w2[85] = 0.544959; 	 w2[86] = -0.640014; 	 w2[87] = 0.263636; 	 w2[88] = 0.163682; 	 w2[89] = -0.434293; 	 w2[90] = -1.804894; 	 w2[91] = -0.845619; 	 w2[92] = 0.451093; 	 w2[93] = 0.457783; 	 w2[94] = 1.453231; 	 w2[95] = 0.463830;
	w2[96] = -0.052493; 	 w2[97] = -0.464887; 	 w2[98] = 0.343082; 	 w2[99] = 0.707481; 	 w2[100] = 0.526036; 	 w2[101] = -0.320935; 	 w2[102] = -0.327922; 	 w2[103] = 0.599802; 	 w2[104] = 0.506368; 	 w2[105] = 0.501144; 	 w2[106] = 0.490187; 	 w2[107] = 0.372165; 	 w2[108] = 0.236718; 	 w2[109] = -0.287655; 	 w2[110] = 0.017460; 	 w2[111] = -0.671526; 	 w2[112] = 0.224023; 	 w2[113] = -0.021420; 	 w2[114] = 0.020866; 	 w2[115] = -0.404318; 	 w2[116] = -0.721102; 	 w2[117] = 0.300294; 	 w2[118] = -0.335743; 	 w2[119] = 0.156145; 	 w2[120] = -0.042642; 	 w2[121] = -0.172538; 	 w2[122] = -0.909761; 	 w2[123] = -0.424076; 	 w2[124] = 0.202119; 	 w2[125] = 0.263886; 	 w2[126] = 0.198486; 	 w2[127] = 0.501662;
	w2[128] = 0.016631; 	 w2[129] = -0.322768; 	 w2[130] = -0.007342; 	 w2[131] = 0.450702; 	 w2[132] = 0.187013; 	 w2[133] = -0.377474; 	 w2[134] = -0.261882; 	 w2[135] = 0.483493; 	 w2[136] = 0.159619; 	 w2[137] = 0.460491; 	 w2[138] = 0.326678; 	 w2[139] = 0.372937; 	 w2[140] = 0.607733; 	 w2[141] = -0.155827; 	 w2[142] = -0.265630; 	 w2[143] = -0.090486; 	 w2[144] = 0.037310; 	 w2[145] = 0.068820; 	 w2[146] = -0.435595; 	 w2[147] = -0.431531; 	 w2[148] = -0.249971; 	 w2[149] = 0.219823; 	 w2[150] = -0.243725; 	 w2[151] = 0.243587; 	 w2[152] = -0.266376; 	 w2[153] = 0.049483; 	 w2[154] = -0.361923; 	 w2[155] = 0.024858; 	 w2[156] = 0.300746; 	 w2[157] = 0.466134; 	 w2[158] = 0.195296; 	 w2[159] = -0.052569;
	w2[160] = -0.510136; 	 w2[161] = 0.076905; 	 w2[162] = -0.502323; 	 w2[163] = 0.257036; 	 w2[164] = 0.124744; 	 w2[165] = -0.719510; 	 w2[166] = -0.111915; 	 w2[167] = 0.301254; 	 w2[168] = 0.073422; 	 w2[169] = 0.277461; 	 w2[170] = 0.232563; 	 w2[171] = -0.091763; 	 w2[172] = -0.416089; 	 w2[173] = -0.124350; 	 w2[174] = -0.419130; 	 w2[175] = 0.385751; 	 w2[176] = 0.423292; 	 w2[177] = 0.254510; 	 w2[178] = 0.271573; 	 w2[179] = 0.002575; 	 w2[180] = -0.250140; 	 w2[181] = 0.167597; 	 w2[182] = -0.148042; 	 w2[183] = -0.359821; 	 w2[184] = -0.012724; 	 w2[185] = -0.055832; 	 w2[186] = -0.474698; 	 w2[187] = -0.461133; 	 w2[188] = -0.113332; 	 w2[189] = -0.089073; 	 w2[190] = -0.391713; 	 w2[191] = 0.457487;
	w2[192] = 0.731573; 	 w2[193] = -1.999794; 	 w2[194] = 0.108967; 	 w2[195] = 2.377160; 	 w2[196] = 2.010096; 	 w2[197] = -0.612092; 	 w2[198] = -1.967856; 	 w2[199] = 2.207363; 	 w2[200] = 1.788775; 	 w2[201] = 1.148119; 	 w2[202] = 2.055217; 	 w2[203] = 1.275283; 	 w2[204] = 2.021610; 	 w2[205] = -0.698662; 	 w2[206] = 0.792278; 	 w2[207] = 0.045977; 	 w2[208] = 0.764634; 	 w2[209] = -0.652804; 	 w2[210] = 1.341723; 	 w2[211] = -2.092837; 	 w2[212] = -2.062000; 	 w2[213] = 0.845251; 	 w2[214] = -2.164820; 	 w2[215] = 0.597929; 	 w2[216] = 0.048878; 	 w2[217] = -0.689077; 	 w2[218] = -2.547419; 	 w2[219] = -2.629596; 	 w2[220] = 1.466667; 	 w2[221] = 1.809848; 	 w2[222] = 3.438903; 	 w2[223] = 0.674659;
	w2[224] = 0.072206; 	 w2[225] = 0.128589; 	 w2[226] = -0.793383; 	 w2[227] = -0.106811; 	 w2[228] = 0.259255; 	 w2[229] = -0.154375; 	 w2[230] = -0.002378; 	 w2[231] = 0.077081; 	 w2[232] = 0.218555; 	 w2[233] = 0.226447; 	 w2[234] = -0.044106; 	 w2[235] = 0.182251; 	 w2[236] = -0.168826; 	 w2[237] = 0.034577; 	 w2[238] = 0.078915; 	 w2[239] = 0.071192; 	 w2[240] = -0.395881; 	 w2[241] = 0.081906; 	 w2[242] = 0.120218; 	 w2[243] = 0.032407; 	 w2[244] = -0.310213; 	 w2[245] = -0.160067; 	 w2[246] = -0.167925; 	 w2[247] = 0.022100; 	 w2[248] = -0.383000; 	 w2[249] = 0.248993; 	 w2[250] = -0.257190; 	 w2[251] = -0.010448; 	 w2[252] = 0.105508; 	 w2[253] = -0.113149; 	 w2[254] = -0.581118; 	 w2[255] = -0.182454;
	w2[256] = -0.249550; 	 w2[257] = 1.099741; 	 w2[258] = -0.080969; 	 w2[259] = -0.874693; 	 w2[260] = -0.543507; 	 w2[261] = 0.143818; 	 w2[262] = 0.454306; 	 w2[263] = -0.549600; 	 w2[264] = -0.434411; 	 w2[265] = -0.348235; 	 w2[266] = -0.836574; 	 w2[267] = -0.525994; 	 w2[268] = -1.092093; 	 w2[269] = 0.118489; 	 w2[270] = -0.312437; 	 w2[271] = 0.190141; 	 w2[272] = -0.610856; 	 w2[273] = 0.095441; 	 w2[274] = -0.780807; 	 w2[275] = 0.681071; 	 w2[276] = 0.646892; 	 w2[277] = -0.161173; 	 w2[278] = 0.522069; 	 w2[279] = -0.260373; 	 w2[280] = -0.214002; 	 w2[281] = 0.383523; 	 w2[282] = 0.976522; 	 w2[283] = 0.425726; 	 w2[284] = -0.216645; 	 w2[285] = -0.637140; 	 w2[286] = -1.876755; 	 w2[287] = -0.262222;
	w2[288] = 0.510904; 	 w2[289] = 0.027430; 	 w2[290] = -0.113410; 	 w2[291] = -1.171924; 	 w2[292] = 0.038471; 	 w2[293] = -0.290220; 	 w2[294] = 0.306490; 	 w2[295] = -0.183599; 	 w2[296] = 0.124956; 	 w2[297] = 0.514640; 	 w2[298] = -0.255999; 	 w2[299] = -0.144729; 	 w2[300] = -0.069507; 	 w2[301] = 0.111432; 	 w2[302] = 0.195156; 	 w2[303] = -6.054498; 	 w2[304] = 0.115876; 	 w2[305] = -0.389804; 	 w2[306] = -0.146668; 	 w2[307] = -0.087863; 	 w2[308] = -0.187930; 	 w2[309] = 0.454334; 	 w2[310] = 0.270430; 	 w2[311] = 0.396545; 	 w2[312] = 0.148085; 	 w2[313] = 0.032273; 	 w2[314] = -0.227267; 	 w2[315] = 0.050101; 	 w2[316] = -0.439085; 	 w2[317] = -0.693663; 	 w2[318] = -1.471004; 	 w2[319] = -0.294920;
	w2[320] = -0.018135; 	 w2[321] = -0.215975; 	 w2[322] = -0.366049; 	 w2[323] = 0.046003; 	 w2[324] = -0.220342; 	 w2[325] = -0.132935; 	 w2[326] = 0.109920; 	 w2[327] = 0.018558; 	 w2[328] = 0.031197; 	 w2[329] = 0.027678; 	 w2[330] = -0.019972; 	 w2[331] = -0.001527; 	 w2[332] = 0.329381; 	 w2[333] = -0.098804; 	 w2[334] = 0.154709; 	 w2[335] = 0.038539; 	 w2[336] = -0.027936; 	 w2[337] = 0.237905; 	 w2[338] = 0.175700; 	 w2[339] = -0.086023; 	 w2[340] = -0.005019; 	 w2[341] = -0.018244; 	 w2[342] = 0.100264; 	 w2[343] = 0.063824; 	 w2[344] = 0.358800; 	 w2[345] = 0.025610; 	 w2[346] = 0.041473; 	 w2[347] = 0.088504; 	 w2[348] = 0.047965; 	 w2[349] = 0.069699; 	 w2[350] = 0.379391; 	 w2[351] = 0.056997;
	w2[352] = -0.162650; 	 w2[353] = -0.246706; 	 w2[354] = -0.035442; 	 w2[355] = 0.323164; 	 w2[356] = 0.487865; 	 w2[357] = -0.438602; 	 w2[358] = -0.186359; 	 w2[359] = 0.561696; 	 w2[360] = 0.400009; 	 w2[361] = 0.266051; 	 w2[362] = 0.441907; 	 w2[363] = 0.299897; 	 w2[364] = -0.306342; 	 w2[365] = -0.381606; 	 w2[366] = -0.088730; 	 w2[367] = 0.140200; 	 w2[368] = 0.201628; 	 w2[369] = -0.178801; 	 w2[370] = -0.190621; 	 w2[371] = -0.324836; 	 w2[372] = -0.720474; 	 w2[373] = 0.367914; 	 w2[374] = -0.209243; 	 w2[375] = 0.037381; 	 w2[376] = 0.024377; 	 w2[377] = -0.141955; 	 w2[378] = -0.817768; 	 w2[379] = -0.365834; 	 w2[380] = 0.222076; 	 w2[381] = 0.235572; 	 w2[382] = 0.141245; 	 w2[383] = 0.270281;
	w2[384] = 0.320788; 	 w2[385] = -1.089983; 	 w2[386] = -0.046285; 	 w2[387] = 1.079026; 	 w2[388] = 0.634462; 	 w2[389] = -0.435926; 	 w2[390] = -0.573046; 	 w2[391] = 0.522824; 	 w2[392] = 0.519437; 	 w2[393] = 0.619094; 	 w2[394] = 0.995377; 	 w2[395] = 0.472240; 	 w2[396] = -0.086168; 	 w2[397] = -0.264548; 	 w2[398] = 0.281379; 	 w2[399] = 0.907190; 	 w2[400] = 0.592900; 	 w2[401] = -0.076803; 	 w2[402] = -0.204567; 	 w2[403] = -0.866342; 	 w2[404] = -0.704150; 	 w2[405] = 0.461747; 	 w2[406] = -0.643449; 	 w2[407] = 0.089811; 	 w2[408] = 0.031089; 	 w2[409] = -0.545955; 	 w2[410] = -1.561265; 	 w2[411] = -0.318909; 	 w2[412] = 0.303546; 	 w2[413] = 0.495390; 	 w2[414] = 1.397912; 	 w2[415] = 0.418977;
	w2[416] = -0.099667; 	 w2[417] = 0.323028; 	 w2[418] = -0.182819; 	 w2[419] = -0.965857; 	 w2[420] = -0.549941; 	 w2[421] = 0.193902; 	 w2[422] = 0.729582; 	 w2[423] = 0.008414; 	 w2[424] = -0.917472; 	 w2[425] = -0.349779; 	 w2[426] = -0.992915; 	 w2[427] = 0.267948; 	 w2[428] = -1.736336; 	 w2[429] = 0.614670; 	 w2[430] = 0.367322; 	 w2[431] = 0.008764; 	 w2[432] = -0.153356; 	 w2[433] = 0.761933; 	 w2[434] = 0.099072; 	 w2[435] = 0.488674; 	 w2[436] = 2.196848; 	 w2[437] = -0.457890; 	 w2[438] = 0.751184; 	 w2[439] = -0.281569; 	 w2[440] = -0.692755; 	 w2[441] = 0.879105; 	 w2[442] = -0.128600; 	 w2[443] = -0.043194; 	 w2[444] = -0.509176; 	 w2[445] = -0.516687; 	 w2[446] = -0.314608; 	 w2[447] = 0.063782;
	w2[448] = 0.048265; 	 w2[449] = 0.622561; 	 w2[450] = -0.091263; 	 w2[451] = -0.684113; 	 w2[452] = -0.580098; 	 w2[453] = 0.372936; 	 w2[454] = 0.518205; 	 w2[455] = -0.299002; 	 w2[456] = -0.531696; 	 w2[457] = -0.848809; 	 w2[458] = -0.737954; 	 w2[459] = 0.083291; 	 w2[460] = -0.150537; 	 w2[461] = 0.391981; 	 w2[462] = -0.113580; 	 w2[463] = -1.720360; 	 w2[464] = -0.351042; 	 w2[465] = -0.021471; 	 w2[466] = -0.601360; 	 w2[467] = 0.681077; 	 w2[468] = 0.426622; 	 w2[469] = -0.184622; 	 w2[470] = 0.225478; 	 w2[471] = -0.250971; 	 w2[472] = -0.243693; 	 w2[473] = 0.611797; 	 w2[474] = 1.197800; 	 w2[475] = 0.255480; 	 w2[476] = -0.561205; 	 w2[477] = -0.514007; 	 w2[478] = -1.113735; 	 w2[479] = -0.142704;
	w2[480] = -0.086151; 	 w2[481] = -0.507904; 	 w2[482] = 0.860617; 	 w2[483] = 0.613823; 	 w2[484] = -0.013975; 	 w2[485] = -0.026891; 	 w2[486] = -0.218012; 	 w2[487] = 0.203450; 	 w2[488] = 0.016287; 	 w2[489] = -0.007422; 	 w2[490] = 0.495767; 	 w2[491] = 0.060043; 	 w2[492] = 0.230622; 	 w2[493] = -0.022178; 	 w2[494] = 0.049502; 	 w2[495] = 1.586623; 	 w2[496] = -0.035545; 	 w2[497] = 0.140152; 	 w2[498] = 0.392854; 	 w2[499] = -0.128025; 	 w2[500] = -0.252567; 	 w2[501] = 0.105945; 	 w2[502] = -0.375442; 	 w2[503] = -0.107640; 	 w2[504] = -0.173454; 	 w2[505] = -0.048757; 	 w2[506] = -0.494138; 	 w2[507] = -0.118787; 	 w2[508] = 0.215382; 	 w2[509] = 0.175726; 	 w2[510] = 0.992709; 	 w2[511] = 0.206766;
	// layer 2 bias
	b2[0] = 0.806161;
	b2[1] = 0.619781;
	b2[2] = -0.609764;
	b2[3] = -0.182383;
	b2[4] = -0.307337;
	b2[5] = -0.645893;
	b2[6] = 0.028189;
	b2[7] = -0.335926;
	b2[8] = 0.090751;
	b2[9] = 0.460366;
	b2[10] = -0.113282;
	b2[11] = -0.283255;
	b2[12] = -0.410993;
	b2[13] = 0.403989;
	b2[14] = 0.168861;
	b2[15] = -0.273244;

	// output weights (linear)
	wo[0] = -0.203273;
	wo[1] = -0.237197;
	wo[2] = 0.353044;
	wo[3] = 0.371979;
	wo[4] = -0.132944;
	wo[5] = 0.329909;
	wo[6] = 0.660572;
	wo[7] = 0.101408;
	wo[8] = 0.642734;
	wo[9] = 0.743450;
	wo[10] = 0.070201;
	wo[11] = 0.339806;
	wo[12] = 0.176282;
	wo[13] = -0.143814;
	wo[14] = 0.238669;
	wo[15] = -0.214066;
	bo = -0.177045;

	end // end of initialization

	vg_s = (V(G,S) - vg_lo) / (vg_hi - vg_lo);
	if (vg_s < 0) vg_s = 0;
	if (vg_s > 1) vg_s = 1;
	vd_s = (V(D,S) - vd_lo) / (vd_hi - vd_lo);
	if (vd_s < 0) vd_s = 0;
	if (vd_s > 1) vd_s = 1;
	width_s = (w - w_lo) / (w_hi - w_lo);
	if (width_s < 0) width_s = 0;
	if (width_s > 1) width_s = 1;
	length_s = (l - l_lo) / (l_hi - l_lo);
	if (length_s < 0) length_s = 0;
	if (length_s > 1) length_s = 1;

	for (i = 0; i < NH1; i = i + 1) begin
		v1[i] = vg_s*w1[NI*i] + vd_s*w1[NI*i+1] + width_s*w1[NI*i+2] + length_s*w1[NI*i+3] + b1[i];
		y1[i] = tanh(v1[i]);
	end

	for (i = 0; i < NH2; i = i + 1) begin
		v2[i] = 0;
		for (j = 0; j < NH1; j = j + 1) begin
			v2[i] = v2[i] + y1[j]*w2[NH1*i+j];
		end
		v2[i] = v2[i] + b2[i];
		y2[i] = tanh(v2[i]);
	end

	log_id = 0;
	for (i = 0; i < NH2; i = i + 1) begin
		log_id = log_id + y2[i]*wo[i];
	end
	log_id = log_id + bo;
	log_id = log_id*y_std + y_mean;   // linear output, then de-standardize
	id = pow(10.0, log_id);

	I(D,S) <+ id;
	I(G,S) <+ 0;
	I(G,D) <+ 0;

	end

endmodule
