// VerilogA for a-IGZO TFT CAMCAS model -- semi-empirical unified DC compact
// model, adapted from Carolina de Almeida's thesis "Development of IGZO
// thin-film transistors (TFTs) compact models" (2025), Sec. 2.3.4 /
// Appendix F, itself based on the CAMCAS (Cambridge Compact Analytical
// Semiconductor) unified TFT model. This is an ALTERNATIVE to this repo's
// ANN-based models (tft_ann_static.va etc.) -- same (VG, VD, W, L) -> ID
// problem, a physics-flavored analytical expression instead of a neural
// network:
//
//   IDS = G0 * (W/L') * exp(kappa*(VGS-Von)^alpha) * VDS' + Ioff
//
// fit separately in the linear (VDS' = VDS - 2*Rc*IDS) and saturation
// (VDS' = VGS-Von, Vds-independent) regimes, blended by the harmonic-mean
// smoothing function Ids_total = (Ids_lin^-m + Ids_sat^-m)^(-1/m) so a
// single expression covers both regimes and the triode-to-saturation
// transition at any Vds.
//
// GEOMETRY HANDLING: nearest-match per-device parameters -- 11
// measured geometries, (160,10), (160,15), (160,20), (160,5), (20,15), (20,20), (20,5), (40,15), (80,10), (80,15), (80,20) um -- selected once at
// initial_step by (w,l) distance (device parameters w, l are fixed per
// instance, so this is zero runtime cost), NOT a continuous (L,W)
// polynomial surface. See scripts/export_verilog_a_camcas.py's docstring
// and outputs_camcas/README.md: on this dataset most of CAMCAS's 10 regime
// parameters don't have a clean geometric trend once real device-to-device
// variation (each (W,L) here is a different physical die site, not a
// repeat measurement) is accounted for, so a smooth surface reproduces even
// its own training geometries very poorly -- confirmed numerically
// (scripts/plot_camcas_fit.py). Per-device, the same functional form
// tracks the measured transfer curves to a median ~15-45% relative error
// depending on geometry and regime (worst near turn-on, matching the
// thesis's own reported weakness there) -- see
// outputs_camcas/camcas_relative_error.csv.
//
// Auto-generated by scripts/export_verilog_a_camcas.py from
// outputs_camcas/extracted_params.csv, outputs_camcas/dl_rsd_per_width.csv.
// Do not hand-edit the per-device parameter tables -- regenerate instead.

`include "constants.h"
`include "disciplines.h"

module tft_camcas_model(D, G, S);
inout G, D, S;
electrical D, G, S;

parameter real w = 80e-6 from [20e-6:160e-6];  // channel width, um range [20,160]
parameter real l = 15e-6 from [5e-6:20e-6];  // channel length, um range [5,20]
parameter real m_smooth = 2.2;  // harmonic-mean smoothing exponent (thesis Eq. 2.35 default)

real Von_lin, Von_sat, alpha_lin, alpha_sat, kappa_lin, kappa_sat;
real G0_lin, G0_sat, Ioff_lin, Ioff_sat, DeltaL, RSD;
real dist, best_dist;
integer dev_sel;

real Wm, Lm, Lp, von_eff, Vgs, Vds;
real x, expo_lin, expo_sat, Gc, ids_lin, ids_sat, ids_total;

analog begin
	@(initial_step or initial_step("static")) begin
	Wm = w*1.0e6;  // this model's parameters were all fit in micrometers
	Lm = l*1.0e6;

	// nearest-match device selection (device parameters w, l are fixed per instance)
	best_dist = 1.0e30;
	dist = pow((w - 160.0e-6)/(160.0e-6-20.0e-6), 2) + pow((l - 10.0e-6)/(20.0e-6-5.0e-6), 2);
	if (dist < best_dist) begin best_dist = dist; dev_sel = 0; end
	dist = pow((w - 160.0e-6)/(160.0e-6-20.0e-6), 2) + pow((l - 15.0e-6)/(20.0e-6-5.0e-6), 2);
	if (dist < best_dist) begin best_dist = dist; dev_sel = 1; end
	dist = pow((w - 160.0e-6)/(160.0e-6-20.0e-6), 2) + pow((l - 20.0e-6)/(20.0e-6-5.0e-6), 2);
	if (dist < best_dist) begin best_dist = dist; dev_sel = 2; end
	dist = pow((w - 160.0e-6)/(160.0e-6-20.0e-6), 2) + pow((l - 5.0e-6)/(20.0e-6-5.0e-6), 2);
	if (dist < best_dist) begin best_dist = dist; dev_sel = 3; end
	dist = pow((w - 20.0e-6)/(160.0e-6-20.0e-6), 2) + pow((l - 15.0e-6)/(20.0e-6-5.0e-6), 2);
	if (dist < best_dist) begin best_dist = dist; dev_sel = 4; end
	dist = pow((w - 20.0e-6)/(160.0e-6-20.0e-6), 2) + pow((l - 20.0e-6)/(20.0e-6-5.0e-6), 2);
	if (dist < best_dist) begin best_dist = dist; dev_sel = 5; end
	dist = pow((w - 20.0e-6)/(160.0e-6-20.0e-6), 2) + pow((l - 5.0e-6)/(20.0e-6-5.0e-6), 2);
	if (dist < best_dist) begin best_dist = dist; dev_sel = 6; end
	dist = pow((w - 40.0e-6)/(160.0e-6-20.0e-6), 2) + pow((l - 15.0e-6)/(20.0e-6-5.0e-6), 2);
	if (dist < best_dist) begin best_dist = dist; dev_sel = 7; end
	dist = pow((w - 80.0e-6)/(160.0e-6-20.0e-6), 2) + pow((l - 10.0e-6)/(20.0e-6-5.0e-6), 2);
	if (dist < best_dist) begin best_dist = dist; dev_sel = 8; end
	dist = pow((w - 80.0e-6)/(160.0e-6-20.0e-6), 2) + pow((l - 15.0e-6)/(20.0e-6-5.0e-6), 2);
	if (dist < best_dist) begin best_dist = dist; dev_sel = 9; end
	dist = pow((w - 80.0e-6)/(160.0e-6-20.0e-6), 2) + pow((l - 20.0e-6)/(20.0e-6-5.0e-6), 2);
	if (dist < best_dist) begin best_dist = dist; dev_sel = 10; end

	if (dev_sel == 0) begin // W=160 L=10 um
		Von_lin = 1.000000e-01;
		Von_sat = 4.000000e-01;
		alpha_lin = -4.458326e-01;
		alpha_sat = -5.798212e-01;
		kappa_lin = -7.006767e+00;
		kappa_sat = -6.169071e+00;
		G0_lin = 9.156021e-05;
		G0_sat = 1.982784e-05;
		Ioff_lin = 8.198000e-13;
		Ioff_sat = 2.333400e-12;
		DeltaL = 1.092501e+00;
		RSD = 1.000000e+01;
	end
	if (dev_sel == 1) begin // W=160 L=15 um
		Von_lin = -7.000000e-01;
		Von_sat = -1.100000e+00;
		alpha_lin = -1.077413e+00;
		alpha_sat = -3.474073e-01;
		kappa_lin = -4.562686e+00;
		kappa_sat = -2.187276e+01;
		G0_lin = 6.407812e-06;
		G0_sat = 6.344619e-01;
		Ioff_lin = 2.181000e-12;
		Ioff_sat = 2.055000e-12;
		DeltaL = 1.092501e+00;
		RSD = 1.000000e+01;
	end
	if (dev_sel == 2) begin // W=160 L=20 um
		Von_lin = -1.000000e-01;
		Von_sat = -3.000000e-01;
		alpha_lin = -4.375341e-01;
		alpha_sat = -5.116869e-01;
		kappa_lin = -4.903592e+00;
		kappa_sat = -8.424895e+00;
		G0_lin = 2.865128e-05;
		G0_sat = 7.004086e-05;
		Ioff_lin = 1.652000e-12;
		Ioff_sat = -4.259000e-12;
		DeltaL = 1.092501e+00;
		RSD = 1.000000e+01;
	end
	if (dev_sel == 3) begin // W=160 L=5 um
		Von_lin = -6.000000e-01;
		Von_sat = -1.000000e-01;
		alpha_lin = -3.524618e-01;
		alpha_sat = -7.832673e-01;
		kappa_lin = -1.450333e+01;
		kappa_sat = -7.619829e+00;
		G0_lin = 8.649776e-03;
		G0_sat = 1.293871e-05;
		Ioff_lin = -1.640000e-13;
		Ioff_sat = 4.793200e-12;
		DeltaL = 1.092501e+00;
		RSD = 1.000000e+01;
	end
	if (dev_sel == 4) begin // W=20 L=15 um
		Von_lin = 0.000000e+00;
		Von_sat = 3.000000e-01;
		alpha_lin = -3.087879e-01;
		alpha_sat = -2.014315e-01;
		kappa_lin = -1.450633e+01;
		kappa_sat = -1.577716e+01;
		G0_lin = 7.485924e-02;
		G0_sat = 2.735935e-01;
		Ioff_lin = -7.550000e-13;
		Ioff_sat = -2.777800e-12;
		DeltaL = 1.170857e-20;
		RSD = 1.000000e+05;
	end
	if (dev_sel == 5) begin // W=20 L=20 um
		Von_lin = 0.000000e+00;
		Von_sat = 0.000000e+00;
		alpha_lin = -8.731134e-01;
		alpha_sat = -8.599841e-01;
		kappa_lin = -3.810947e+00;
		kappa_sat = -4.141557e+00;
		G0_lin = 1.500887e-05;
		G0_sat = 5.088341e-06;
		Ioff_lin = 2.371000e-12;
		Ioff_sat = 2.076800e-12;
		DeltaL = 1.170857e-20;
		RSD = 1.000000e+05;
	end
	if (dev_sel == 6) begin // W=20 L=5 um
		Von_lin = 1.100000e+00;
		Von_sat = 1.200000e+00;
		alpha_lin = -4.753895e-01;
		alpha_sat = -6.112608e-01;
		kappa_lin = -9.992798e+00;
		kappa_sat = -7.055371e+00;
		G0_lin = 9.611860e-04;
		G0_sat = 1.491796e-05;
		Ioff_lin = 4.776000e-12;
		Ioff_sat = 3.009600e-12;
		DeltaL = 1.170857e-20;
		RSD = 1.000000e+05;
	end
	if (dev_sel == 7) begin // W=40 L=15 um
		Von_lin = -1.000000e-01;
		Von_sat = 2.000000e-01;
		alpha_lin = -2.224555e-01;
		alpha_sat = -3.792889e-01;
		kappa_lin = -1.640712e+01;
		kappa_sat = -8.937753e+00;
		G0_lin = 9.212137e-01;
		G0_sat = 2.077038e-04;
		Ioff_lin = 7.964000e-13;
		Ioff_sat = -4.304800e-12;
		DeltaL = 4.000000e+00;
		RSD = 1.000000e+01;
	end
	if (dev_sel == 8) begin // W=80 L=10 um
		Von_lin = 0.000000e+00;
		Von_sat = 4.000000e-01;
		alpha_lin = -4.638284e-01;
		alpha_sat = -2.627204e-01;
		kappa_lin = -1.130735e+01;
		kappa_sat = -1.163186e+01;
		G0_lin = 4.525301e-03;
		G0_sat = 4.037096e-03;
		Ioff_lin = 2.770400e-12;
		Ioff_sat = -4.687600e-12;
		DeltaL = 2.466339e-19;
		RSD = 2.465694e+04;
	end
	if (dev_sel == 9) begin // W=80 L=15 um
		Von_lin = -5.000000e-01;
		Von_sat = 0.000000e+00;
		alpha_lin = -4.721356e-01;
		alpha_sat = -2.047925e-01;
		kappa_lin = -1.233339e+01;
		kappa_sat = -1.673392e+01;
		G0_lin = 6.421740e-03;
		G0_sat = 5.181834e-01;
		Ioff_lin = 2.117400e-12;
		Ioff_sat = -4.779600e-12;
		DeltaL = 2.466339e-19;
		RSD = 2.465694e+04;
	end
	if (dev_sel == 10) begin // W=80 L=20 um
		Von_lin = -3.000000e-01;
		Von_sat = -1.000000e-01;
		alpha_lin = -3.629253e-01;
		alpha_sat = -4.385307e-01;
		kappa_lin = -9.246602e+00;
		kappa_sat = -6.486743e+00;
		G0_lin = 2.209624e-03;
		G0_sat = 7.453566e-05;
		Ioff_lin = -4.828400e-12;
		Ioff_sat = -1.201000e-12;
		DeltaL = 2.466339e-19;
		RSD = 2.465694e+04;
	end

	end // end of initialization

	Vgs = V(G,S);
	Vds = V(D,S);
	Lp = Lm - DeltaL;
	if (Lp < 0.1) Lp = 0.1;
	if (Von_lin > Von_sat)
		von_eff = Von_lin;
	else
		von_eff = Von_sat;

	if (Vgs <= von_eff) begin
		// off-state: constant-current floor from whichever regime applies
		if (Vds < (Vgs - von_eff))
			ids_total = Ioff_lin;
		else
			ids_total = Ioff_sat;
	end else begin
		x = Vgs - von_eff;

		expo_lin = kappa_lin * pow(x, alpha_lin);
		if (expo_lin > 700.0) expo_lin = 700.0;
		if (expo_lin < -700.0) expo_lin = -700.0;
		Gc = G0_lin * (Wm/Lp) * exp(expo_lin);
		// linear branch: ACTUAL Vds (not a fixed reference) so the harmonic
		// mean below can hand off to the Vds-independent saturation branch
		// as Vds grows -- get this wrong and the model can never saturate.
		ids_lin = (Gc*Vds + Ioff_lin) / (1 + RSD*Gc);
		if (ids_lin < 1e-15) ids_lin = 1e-15;

		expo_sat = kappa_sat * pow(x, alpha_sat);
		if (expo_sat > 700.0) expo_sat = 700.0;
		if (expo_sat < -700.0) expo_sat = -700.0;
		ids_sat = G0_sat * (Wm/Lp) * exp(expo_sat) * x + Ioff_sat;
		if (ids_sat < 1e-15) ids_sat = 1e-15;

		ids_total = pow(pow(ids_lin, -m_smooth) + pow(ids_sat, -m_smooth), -1.0/m_smooth);
	end

	I(D,S) <+ ids_total;
end

endmodule
