// VerilogA for a-IGZO TFT -- UNIFIED CAMCAS compact DC model.
//
// Semi-empirical unified drain-current model from Carolina de Almeida's
// thesis "Development of IGZO thin-film transistors (TFTs) compact models"
// (2025), Sec. 2.3.4 / Appendix F (CAMCAS), fit to this repo's measured data
// (data_cleaned_2) with ONE fixed parameter set valid for every geometry:
// (w, l) enter only through W/L' (L' = L - DeltaL) and RSD = Rsw/W. No
// per-device tables, no (L, W) polynomial surfaces.
//
//   G(VGS) = GH * (W/L') * exp( s*((x/xH)^alpha - 1)/alpha ),
//            x = VGS - Von, xH = VH - Von          (per branch: lin, sat)
//   I_lin  = G_lin*VDS / (1 + RSD*G_lin)
//   I_sat  = G_sat * (VGS - Von_sat)
//   IDS    = (I_lin^-m + I_sat^-m)^(-1/m) + Ioff
//
// The G expression is the thesis's G0*(W/L')*exp(kappa*x^alpha) rewritten
// around the reference point VGS = VH (kappa = s/(alpha*xH^alpha),
// G0 = GH*exp(-kappa*xH^alpha)) -- same curve, better-conditioned fit.
// Thesis-notation equivalents of the values below:
//   lin: Von=-0.4848 V  alpha=-0.6430  kappa=-6.9636  G0=6.5897e-05 S
//   sat: Von=-2.2028 V  alpha=-3.1302  kappa=-229.0968  G0=2.3202e-06 S
//
// Fit jointly (linear transfer, saturation transfer and output curves, in
// log10|ID|) to the 13 "golden" devices that agree with the process
// consensus: W/L = 20/10, 20/15, 20/20, 40/5, 40/10, 40/15, 80/5, 80/10, 80/15, 80/20, 160/5, 160/10, 160/20 um. DeltaL comes from a width-normalized TLM over those
// devices. Leave-one-device-out cross-validation: mean held-out error
// 0.290 decades of log10|ID| (geometry never seen by the fit). See
// outputs_camcas/README.md for accuracy vs. this repo's ANN.
//
// Robustness additions (no effect at measured bias points): source/drain
// swap for VDS < 0; Ioff scaled by tanh(VDS/20mV) so I=0 at VDS=0.
//
// Auto-generated by scripts/export_verilog_a_camcas_unified.py -- regenerate,
// don't hand-edit.

`include "constants.h"
`include "disciplines.h"

module tft_camcas_unified(D, G, S);
inout D, G, S;
electrical D, G, S;

parameter real w = 40e-6 from [5e-6:160e-6];  // channel width (m)
parameter real l = 10e-6 from [5e-6:20e-6];   // channel length (m)

// unified model parameters -- the same for every device
parameter real VH        = 5;          // reference gate voltage (V)
parameter real Von_lin   = -0.48481272;
parameter real Von_sat   = -2.2027515;
parameter real lnGH_lin  = -11.958384;    // ln(S) per unit W/L'
parameter real lnGH_sat  = -13.447924;
parameter real s_lin     = 1.4988735;
parameter real s_sat     = 1.4839657;
parameter real alpha_lin = -0.64302672;
parameter real alpha_sat = -3.1302356;
parameter real DeltaL    = -3.6035214;      // um (negative: L_eff > L_drawn)
parameter real Rsw       = 406984.05;         // Ohm*um  (RSD = Rsw/W)
parameter real m_smooth  = 2.8525622;
parameter real Ioff      = 2.69551425e-12;        // A

real Wm, Lp, wl, rsd;
real vgs, vds, sgn;
real x, g_lin, g_sat, G_lin, i_lin, i_sat, lo, hi, ids;

analog function real gsheet;
	input vg, von, lnGH, s, alpha, vh;
	real vg, von, lnGH, s, alpha, vh, xx, arg;
	begin
		xx = vg - von;
		if (xx <= 1.0e-9)
			gsheet = 0.0;
		else begin
			arg = lnGH + s * (pow(xx / (vh - von), alpha) - 1.0) / alpha;
			if (arg < -700.0) arg = -700.0;
			gsheet = exp(arg);
		end
	end
endfunction

analog begin
	// parameter-only terms; no initial_step block so OpenVAF (ngspice/Xyce
	// OSDI) compiles this as well as Spectre
	Wm = w * 1.0e6;
	Lp = l * 1.0e6 - DeltaL;
	if (Lp < 0.5) Lp = 0.5;
	wl = Wm / Lp;
	rsd = Rsw / Wm;

	if (V(D,S) >= 0.0) begin
		sgn = 1.0;
		vgs = V(G,S);
		vds = V(D,S);
	end else begin
		sgn = -1.0;
		vgs = V(G,D);
		vds = V(S,D);
	end

	g_lin = gsheet(vgs, Von_lin, lnGH_lin, s_lin, alpha_lin, VH);
	g_sat = gsheet(vgs, Von_sat, lnGH_sat, s_sat, alpha_sat, VH);
	x = vgs - Von_sat;
	if (x < 0.0) x = 0.0;

	G_lin = g_lin * wl;
	i_lin = G_lin * vds / (1.0 + rsd * G_lin);
	i_sat = g_sat * wl * x;
	if (i_lin < 1.0e-30) i_lin = 1.0e-30;
	if (i_sat < 1.0e-30) i_sat = 1.0e-30;

	// harmonic mean (i_lin^-m + i_sat^-m)^(-1/m), overflow-safe form
	lo = min(i_lin, i_sat);
	hi = max(i_lin, i_sat);
	ids = lo * pow(1.0 + pow(lo / hi, m_smooth), -1.0 / m_smooth)
	      + Ioff * tanh(vds / 0.02);

	I(D,S) <+ sgn * ids;
end

endmodule
