// VerilogA for a-IGZO TFT ANN FULL behavioural model -- ID + CGD + CGS.
//
// Three separate ANNs, one per element of the equivalent circuit, joined as
// the EC prescribes -- Bahubalindruni et al., "InGaZnO TFT behavioral model
// for IC design", Analog Integr Circ Sig Process (2016) 87:73-80, Fig. 1(b):
// "Each electrical element in the EC is modeled with an ANN ... these ANNs
// are connected together as per the EC".
//
//     ID  : current source across D-S      -- 4 -> 32 -> 16 -> 1
//     CGD : capacitor across G-D           -- 4 -> 18 -> 9 -> 1
//     CGS : capacitor across G-S           -- 4 -> 20 -> 10 -> 1
//
// All three networks use the paper's Eqs. (1)-(2) form -- tanh hidden layers,
// linear output layer -- and the identical 4-input interface (VG, VD, W, L)
// with the identical min-max [0,1] input scaling, so they are pin-compatible
// and every element supports continuous (W, L) geometry scaling.
//
// ID   target: log10(|ID|), standardised. Source trained_ANN/deep/weights.json
//              (2-hidden-layer variant of tft_ann_static.va, trained with the
//              monotonicity penalty + L-balanced loss; see
//              scripts/export_verilog_a_deep.py).
// CGD  target: C/(W*L) [pF/um^2], standardised. loss=huber, lr=0.005, batch=32
// CGS  target: C/(W*L) [pF/um^2], standardised. loss=mse, lr=0.005, batch=16
//              Sources trained_Cg_ANN/{cgd,cgs}/weights.json.
//
// *** CAVEAT -- CGD/CGS HAVE NO REAL VDS DEPENDENCE ***
// VD is present as an input for pin-compatibility with the ID network, but
// every C-V measurement behind these two ANNs was taken at a single VDS = 0 V
// bias (data_cleaned_cv/), so the networks cannot have learnt any VDS
// dependence -- they are effectively C(VG, W, L). The paper's own CGSi/CGDi
// model does depend on VDS and reproduces the saturation-region asymmetry
// (CGDi -> 0, CGSi -> 2/3 CCH, its Figs. 5-6); this module does NOT. Adding
// that requires C-V data swept over VDS.
// Geometry coverage of the capacitance ANNs is also thinner than the ID
// network's: 4 measured (W, L) points -- (20,20), (40,20), (160,15), (160,20)
// um -- versus 19 for ID, so CGD/CGS extrapolate outside that hull.
//
// Auto-generated by scripts/export_verilog_a_full.py.
// Do not hand-edit the weight/bias tables -- regenerate instead.

`include "constants.h"
`include "disciplines.h"

module tft_ann_full_model(D, G, S);
inout G, D, S;
electrical D, G, S;

parameter integer NI = 4;          // shared inputs: VG, VD, W, L
parameter integer ID_NH1  = 32;   // ID  hidden layer 1
parameter integer ID_NH2  = 16;   // ID  hidden layer 2
parameter integer CGD_NH1 = 18;   // CGD hidden layer 1
parameter integer CGD_NH2 = 9;    // CGD hidden layer 2
parameter integer CGS_NH1 = 20;   // CGS hidden layer 1
parameter integer CGS_NH2 = 10;   // CGS hidden layer 2

// device geometry (SI units, Spectre convention)
parameter real w = 40e-6 from [5e-6:160e-6];  // channel width,  training range [5,160] um
parameter real l = 20e-6 from [5e-6:20e-6];  // channel length, training range [5,20] um

// ---- ID network ----
real id_w1[0:(NI*ID_NH1)-1];      real id_b1[0:ID_NH1-1];
real id_v1[0:ID_NH1-1];           real id_y1[0:ID_NH1-1];
real id_w2[0:(ID_NH1*ID_NH2)-1];  real id_b2[0:ID_NH2-1];
real id_v2[0:ID_NH2-1];           real id_y2[0:ID_NH2-1];
real id_wo[0:ID_NH2-1];           real id_bo;
real id_y_mean, id_y_std;
real log_id, id, id_out;
real gm, gds, dvg, dvd, s_vg, s_vd;

// ---- CGD network ----
real cgd_w1[0:(NI*CGD_NH1)-1];      real cgd_b1[0:CGD_NH1-1];
real cgd_y1[0:CGD_NH1-1];
real cgd_w2[0:(CGD_NH1*CGD_NH2)-1]; real cgd_b2[0:CGD_NH2-1];
real cgd_y2[0:CGD_NH2-1];           real cgd_acc;
real cgd_wo[0:CGD_NH2-1];           real cgd_bo;
real cgd_y_mean, cgd_y_std;
real cgd, cgd_out, qgd;

// ---- CGS network ----
real cgs_w1[0:(NI*CGS_NH1)-1];      real cgs_b1[0:CGS_NH1-1];
real cgs_y1[0:CGS_NH1-1];
real cgs_w2[0:(CGS_NH1*CGS_NH2)-1]; real cgs_b2[0:CGS_NH2-1];
real cgs_y2[0:CGS_NH2-1];           real cgs_acc;
real cgs_wo[0:CGS_NH2-1];           real cgs_bo;
real cgs_y_mean, cgs_y_std;
real cgs, cgs_out, qgs;

// ---- shared preprocessing ----
real vg_lo, vg_hi, vd_lo, vd_hi, w_lo, w_hi, l_lo, l_hi;
real vg_s, vd_s, width_s, length_s;
integer i, j;

analog begin
	@(initial_step or initial_step("static")) begin

	vg_lo = -5.000000; vg_hi = 5.000000;
	vd_lo = 0.000000; vd_hi = 5.000000;
	w_lo  = 5.0e-6; w_hi  = 160.0e-6;
	l_lo  = 5.0e-6; l_hi  = 20.0e-6;

	// ================= ID network =================
	id_y_mean = -8.520563;
	id_y_std  = 3.184171;

	// hidden layer 1 weights: id_w1[NI*i + k], k in {0:VG, 1:VD, 2:W, 3:L}
	id_w1[0] = 0.489155; 	 id_w1[1] = 0.973930; 	 id_w1[2] = 0.188468; 	 id_w1[3] = 0.390691;
	id_w1[4] = -1.213416; 	 id_w1[5] = 0.051716; 	 id_w1[6] = -0.263094; 	 id_w1[7] = 0.004503;
	id_w1[8] = 0.399144; 	 id_w1[9] = -4.443088; 	 id_w1[10] = -0.019902; 	 id_w1[11] = 0.107949;
	id_w1[12] = 3.097643; 	 id_w1[13] = -0.141100; 	 id_w1[14] = -0.175611; 	 id_w1[15] = -0.162886;
	id_w1[16] = 0.946950; 	 id_w1[17] = 0.073139; 	 id_w1[18] = -0.112898; 	 id_w1[19] = 0.367862;
	id_w1[20] = -0.744254; 	 id_w1[21] = -0.115568; 	 id_w1[22] = -0.138068; 	 id_w1[23] = 0.360483;
	id_w1[24] = -1.583334; 	 id_w1[25] = -0.029043; 	 id_w1[26] = 0.020400; 	 id_w1[27] = -0.121902;
	id_w1[28] = -0.684513; 	 id_w1[29] = 0.003283; 	 id_w1[30] = 3.729250; 	 id_w1[31] = -2.785446;
	id_w1[32] = 1.081669; 	 id_w1[33] = 0.033492; 	 id_w1[34] = -0.336108; 	 id_w1[35] = 0.424874;
	id_w1[36] = 0.711425; 	 id_w1[37] = 0.406471; 	 id_w1[38] = 0.230302; 	 id_w1[39] = 0.053443;
	id_w1[40] = 1.324099; 	 id_w1[41] = -0.331033; 	 id_w1[42] = -0.147411; 	 id_w1[43] = 0.292915;
	id_w1[44] = 0.546763; 	 id_w1[45] = -0.282531; 	 id_w1[46] = 0.598534; 	 id_w1[47] = 0.434796;
	id_w1[48] = 0.313749; 	 id_w1[49] = 0.004218; 	 id_w1[50] = -4.996068; 	 id_w1[51] = 1.914150;
	id_w1[52] = -0.879493; 	 id_w1[53] = 0.669350; 	 id_w1[54] = 0.105767; 	 id_w1[55] = 0.172122;
	id_w1[56] = 0.337918; 	 id_w1[57] = 0.006678; 	 id_w1[58] = 0.405560; 	 id_w1[59] = -0.053739;
	id_w1[60] = 0.102990; 	 id_w1[61] = -25.760262; 	 id_w1[62] = 0.075716; 	 id_w1[63] = 0.023758;
	id_w1[64] = 0.318733; 	 id_w1[65] = 0.086756; 	 id_w1[66] = 0.664442; 	 id_w1[67] = -4.413779;
	id_w1[68] = -0.545077; 	 id_w1[69] = -0.274910; 	 id_w1[70] = 0.061456; 	 id_w1[71] = 0.029132;
	id_w1[72] = 1.125248; 	 id_w1[73] = -0.071040; 	 id_w1[74] = -1.973062; 	 id_w1[75] = -5.072545;
	id_w1[76] = -1.246557; 	 id_w1[77] = -0.160224; 	 id_w1[78] = -0.146388; 	 id_w1[79] = -0.043302;
	id_w1[80] = -1.470429; 	 id_w1[81] = -0.179616; 	 id_w1[82] = 0.386832; 	 id_w1[83] = -0.177040;
	id_w1[84] = 1.010652; 	 id_w1[85] = 0.184310; 	 id_w1[86] = 0.222876; 	 id_w1[87] = -0.317393;
	id_w1[88] = -1.261151; 	 id_w1[89] = 0.052041; 	 id_w1[90] = -0.013068; 	 id_w1[91] = -0.303475;
	id_w1[92] = 0.453865; 	 id_w1[93] = 0.350297; 	 id_w1[94] = 0.124348; 	 id_w1[95] = -0.025576;
	id_w1[96] = 0.648999; 	 id_w1[97] = 0.039723; 	 id_w1[98] = -0.172135; 	 id_w1[99] = -0.874843;
	id_w1[100] = -0.648376; 	 id_w1[101] = 0.260334; 	 id_w1[102] = 0.366178; 	 id_w1[103] = -0.007695;
	id_w1[104] = -0.876389; 	 id_w1[105] = -0.095522; 	 id_w1[106] = -0.457587; 	 id_w1[107] = -0.570804;
	id_w1[108] = -2.145184; 	 id_w1[109] = 0.004233; 	 id_w1[110] = 5.709260; 	 id_w1[111] = 3.729073;
	id_w1[112] = 1.650931; 	 id_w1[113] = -0.265010; 	 id_w1[114] = -0.116123; 	 id_w1[115] = 0.023128;
	id_w1[116] = 2.114063; 	 id_w1[117] = -0.085739; 	 id_w1[118] = 0.128350; 	 id_w1[119] = -0.025990;
	id_w1[120] = 3.053837; 	 id_w1[121] = 0.095287; 	 id_w1[122] = 0.218960; 	 id_w1[123] = -0.197283;
	id_w1[124] = 0.208949; 	 id_w1[125] = -0.008235; 	 id_w1[126] = -0.474339; 	 id_w1[127] = -6.954501;
	// hidden layer 1 bias
	id_b1[0] = 0.563700;
	id_b1[1] = 0.385136;
	id_b1[2] = -0.604453;
	id_b1[3] = -0.871648;
	id_b1[4] = -0.704905;
	id_b1[5] = 0.733962;
	id_b1[6] = 0.484576;
	id_b1[7] = -1.361373;
	id_b1[8] = -0.806255;
	id_b1[9] = -0.678429;
	id_b1[10] = -0.651912;
	id_b1[11] = -0.632606;
	id_b1[12] = -0.343287;
	id_b1[13] = 0.142369;
	id_b1[14] = 0.152639;
	id_b1[15] = -0.444058;
	id_b1[16] = -0.759782;
	id_b1[17] = 0.171465;
	id_b1[18] = 0.377838;
	id_b1[19] = 0.635626;
	id_b1[20] = 0.784596;
	id_b1[21] = -0.743621;
	id_b1[22] = 0.571653;
	id_b1[23] = -0.225234;
	id_b1[24] = 0.097915;
	id_b1[25] = 0.277337;
	id_b1[26] = 1.123474;
	id_b1[27] = -1.699205;
	id_b1[28] = -0.192815;
	id_b1[29] = -0.403361;
	id_b1[30] = -0.958974;
	id_b1[31] = 0.111784;

	// hidden layer 2 weights: id_w2[ID_NH1*i + j]
	id_w2[0] = 0.532267; 	 id_w2[1] = 0.003397; 	 id_w2[2] = 0.055603; 	 id_w2[3] = -0.461591; 	 id_w2[4] = -0.124538; 	 id_w2[5] = 0.267358; 	 id_w2[6] = -0.031885; 	 id_w2[7] = 0.126987; 	 id_w2[8] = -0.140142; 	 id_w2[9] = -0.482824; 	 id_w2[10] = -0.214335; 	 id_w2[11] = -0.047892; 	 id_w2[12] = -0.127188; 	 id_w2[13] = 0.056478; 	 id_w2[14] = 0.273461; 	 id_w2[15] = -0.240251; 	 id_w2[16] = -0.279261; 	 id_w2[17] = -0.036033; 	 id_w2[18] = 0.098669; 	 id_w2[19] = -0.078410; 	 id_w2[20] = 0.338413; 	 id_w2[21] = 0.063184; 	 id_w2[22] = 0.077756; 	 id_w2[23] = 0.030734; 	 id_w2[24] = -0.023782; 	 id_w2[25] = -0.082329; 	 id_w2[26] = 0.599347; 	 id_w2[27] = -0.994188; 	 id_w2[28] = 0.046009; 	 id_w2[29] = 0.115286; 	 id_w2[30] = 0.154290; 	 id_w2[31] = -0.306457;
	id_w2[32] = 0.379405; 	 id_w2[33] = 0.231843; 	 id_w2[34] = 0.447823; 	 id_w2[35] = -0.408439; 	 id_w2[36] = -0.166371; 	 id_w2[37] = 0.641330; 	 id_w2[38] = 0.219686; 	 id_w2[39] = -0.343732; 	 id_w2[40] = -0.211880; 	 id_w2[41] = -0.230118; 	 id_w2[42] = -0.149769; 	 id_w2[43] = -0.065510; 	 id_w2[44] = 0.336822; 	 id_w2[45] = 0.121062; 	 id_w2[46] = 0.214365; 	 id_w2[47] = -0.346814; 	 id_w2[48] = -0.536465; 	 id_w2[49] = -0.156374; 	 id_w2[50] = 0.365440; 	 id_w2[51] = 0.208579; 	 id_w2[52] = 0.012371; 	 id_w2[53] = -0.365195; 	 id_w2[54] = 0.183527; 	 id_w2[55] = 0.313311; 	 id_w2[56] = -0.239014; 	 id_w2[57] = 0.016356; 	 id_w2[58] = 0.773058; 	 id_w2[59] = 0.478281; 	 id_w2[60] = -0.271077; 	 id_w2[61] = 0.103479; 	 id_w2[62] = 0.060671; 	 id_w2[63] = -0.121533;
	id_w2[64] = -0.047792; 	 id_w2[65] = -0.591728; 	 id_w2[66] = 0.089046; 	 id_w2[67] = 0.876157; 	 id_w2[68] = 0.680588; 	 id_w2[69] = -0.730789; 	 id_w2[70] = -0.707075; 	 id_w2[71] = 0.706061; 	 id_w2[72] = 0.862750; 	 id_w2[73] = 0.720040; 	 id_w2[74] = 1.122934; 	 id_w2[75] = 0.667764; 	 id_w2[76] = -0.100353; 	 id_w2[77] = -0.499272; 	 id_w2[78] = -0.104804; 	 id_w2[79] = -1.130242; 	 id_w2[80] = 0.710169; 	 id_w2[81] = -0.363320; 	 id_w2[82] = 0.430024; 	 id_w2[83] = -0.766011; 	 id_w2[84] = -0.961710; 	 id_w2[85] = 0.544959; 	 id_w2[86] = -0.640014; 	 id_w2[87] = 0.263636; 	 id_w2[88] = 0.163682; 	 id_w2[89] = -0.434293; 	 id_w2[90] = -1.804894; 	 id_w2[91] = -0.845619; 	 id_w2[92] = 0.451093; 	 id_w2[93] = 0.457783; 	 id_w2[94] = 1.453231; 	 id_w2[95] = 0.463830;
	id_w2[96] = -0.052493; 	 id_w2[97] = -0.464887; 	 id_w2[98] = 0.343082; 	 id_w2[99] = 0.707481; 	 id_w2[100] = 0.526036; 	 id_w2[101] = -0.320935; 	 id_w2[102] = -0.327922; 	 id_w2[103] = 0.599802; 	 id_w2[104] = 0.506368; 	 id_w2[105] = 0.501144; 	 id_w2[106] = 0.490187; 	 id_w2[107] = 0.372165; 	 id_w2[108] = 0.236718; 	 id_w2[109] = -0.287655; 	 id_w2[110] = 0.017460; 	 id_w2[111] = -0.671526; 	 id_w2[112] = 0.224023; 	 id_w2[113] = -0.021420; 	 id_w2[114] = 0.020866; 	 id_w2[115] = -0.404318; 	 id_w2[116] = -0.721102; 	 id_w2[117] = 0.300294; 	 id_w2[118] = -0.335743; 	 id_w2[119] = 0.156145; 	 id_w2[120] = -0.042642; 	 id_w2[121] = -0.172538; 	 id_w2[122] = -0.909761; 	 id_w2[123] = -0.424076; 	 id_w2[124] = 0.202119; 	 id_w2[125] = 0.263886; 	 id_w2[126] = 0.198486; 	 id_w2[127] = 0.501662;
	id_w2[128] = 0.016631; 	 id_w2[129] = -0.322768; 	 id_w2[130] = -0.007342; 	 id_w2[131] = 0.450702; 	 id_w2[132] = 0.187013; 	 id_w2[133] = -0.377474; 	 id_w2[134] = -0.261882; 	 id_w2[135] = 0.483493; 	 id_w2[136] = 0.159619; 	 id_w2[137] = 0.460491; 	 id_w2[138] = 0.326678; 	 id_w2[139] = 0.372937; 	 id_w2[140] = 0.607733; 	 id_w2[141] = -0.155827; 	 id_w2[142] = -0.265630; 	 id_w2[143] = -0.090486; 	 id_w2[144] = 0.037310; 	 id_w2[145] = 0.068820; 	 id_w2[146] = -0.435595; 	 id_w2[147] = -0.431531; 	 id_w2[148] = -0.249971; 	 id_w2[149] = 0.219823; 	 id_w2[150] = -0.243725; 	 id_w2[151] = 0.243587; 	 id_w2[152] = -0.266376; 	 id_w2[153] = 0.049483; 	 id_w2[154] = -0.361923; 	 id_w2[155] = 0.024858; 	 id_w2[156] = 0.300746; 	 id_w2[157] = 0.466134; 	 id_w2[158] = 0.195296; 	 id_w2[159] = -0.052569;
	id_w2[160] = -0.510136; 	 id_w2[161] = 0.076905; 	 id_w2[162] = -0.502323; 	 id_w2[163] = 0.257036; 	 id_w2[164] = 0.124744; 	 id_w2[165] = -0.719510; 	 id_w2[166] = -0.111915; 	 id_w2[167] = 0.301254; 	 id_w2[168] = 0.073422; 	 id_w2[169] = 0.277461; 	 id_w2[170] = 0.232563; 	 id_w2[171] = -0.091763; 	 id_w2[172] = -0.416089; 	 id_w2[173] = -0.124350; 	 id_w2[174] = -0.419130; 	 id_w2[175] = 0.385751; 	 id_w2[176] = 0.423292; 	 id_w2[177] = 0.254510; 	 id_w2[178] = 0.271573; 	 id_w2[179] = 0.002575; 	 id_w2[180] = -0.250140; 	 id_w2[181] = 0.167597; 	 id_w2[182] = -0.148042; 	 id_w2[183] = -0.359821; 	 id_w2[184] = -0.012724; 	 id_w2[185] = -0.055832; 	 id_w2[186] = -0.474698; 	 id_w2[187] = -0.461133; 	 id_w2[188] = -0.113332; 	 id_w2[189] = -0.089073; 	 id_w2[190] = -0.391713; 	 id_w2[191] = 0.457487;
	id_w2[192] = 0.731573; 	 id_w2[193] = -1.999794; 	 id_w2[194] = 0.108967; 	 id_w2[195] = 2.377160; 	 id_w2[196] = 2.010096; 	 id_w2[197] = -0.612092; 	 id_w2[198] = -1.967856; 	 id_w2[199] = 2.207363; 	 id_w2[200] = 1.788775; 	 id_w2[201] = 1.148119; 	 id_w2[202] = 2.055217; 	 id_w2[203] = 1.275283; 	 id_w2[204] = 2.021610; 	 id_w2[205] = -0.698662; 	 id_w2[206] = 0.792278; 	 id_w2[207] = 0.045977; 	 id_w2[208] = 0.764634; 	 id_w2[209] = -0.652804; 	 id_w2[210] = 1.341723; 	 id_w2[211] = -2.092837; 	 id_w2[212] = -2.062000; 	 id_w2[213] = 0.845251; 	 id_w2[214] = -2.164820; 	 id_w2[215] = 0.597929; 	 id_w2[216] = 0.048878; 	 id_w2[217] = -0.689077; 	 id_w2[218] = -2.547419; 	 id_w2[219] = -2.629596; 	 id_w2[220] = 1.466667; 	 id_w2[221] = 1.809848; 	 id_w2[222] = 3.438903; 	 id_w2[223] = 0.674659;
	id_w2[224] = 0.072206; 	 id_w2[225] = 0.128589; 	 id_w2[226] = -0.793383; 	 id_w2[227] = -0.106811; 	 id_w2[228] = 0.259255; 	 id_w2[229] = -0.154375; 	 id_w2[230] = -0.002378; 	 id_w2[231] = 0.077081; 	 id_w2[232] = 0.218555; 	 id_w2[233] = 0.226447; 	 id_w2[234] = -0.044106; 	 id_w2[235] = 0.182251; 	 id_w2[236] = -0.168826; 	 id_w2[237] = 0.034577; 	 id_w2[238] = 0.078915; 	 id_w2[239] = 0.071192; 	 id_w2[240] = -0.395881; 	 id_w2[241] = 0.081906; 	 id_w2[242] = 0.120218; 	 id_w2[243] = 0.032407; 	 id_w2[244] = -0.310213; 	 id_w2[245] = -0.160067; 	 id_w2[246] = -0.167925; 	 id_w2[247] = 0.022100; 	 id_w2[248] = -0.383000; 	 id_w2[249] = 0.248993; 	 id_w2[250] = -0.257190; 	 id_w2[251] = -0.010448; 	 id_w2[252] = 0.105508; 	 id_w2[253] = -0.113149; 	 id_w2[254] = -0.581118; 	 id_w2[255] = -0.182454;
	id_w2[256] = -0.249550; 	 id_w2[257] = 1.099741; 	 id_w2[258] = -0.080969; 	 id_w2[259] = -0.874693; 	 id_w2[260] = -0.543507; 	 id_w2[261] = 0.143818; 	 id_w2[262] = 0.454306; 	 id_w2[263] = -0.549600; 	 id_w2[264] = -0.434411; 	 id_w2[265] = -0.348235; 	 id_w2[266] = -0.836574; 	 id_w2[267] = -0.525994; 	 id_w2[268] = -1.092093; 	 id_w2[269] = 0.118489; 	 id_w2[270] = -0.312437; 	 id_w2[271] = 0.190141; 	 id_w2[272] = -0.610856; 	 id_w2[273] = 0.095441; 	 id_w2[274] = -0.780807; 	 id_w2[275] = 0.681071; 	 id_w2[276] = 0.646892; 	 id_w2[277] = -0.161173; 	 id_w2[278] = 0.522069; 	 id_w2[279] = -0.260373; 	 id_w2[280] = -0.214002; 	 id_w2[281] = 0.383523; 	 id_w2[282] = 0.976522; 	 id_w2[283] = 0.425726; 	 id_w2[284] = -0.216645; 	 id_w2[285] = -0.637140; 	 id_w2[286] = -1.876755; 	 id_w2[287] = -0.262222;
	id_w2[288] = 0.510904; 	 id_w2[289] = 0.027430; 	 id_w2[290] = -0.113410; 	 id_w2[291] = -1.171924; 	 id_w2[292] = 0.038471; 	 id_w2[293] = -0.290220; 	 id_w2[294] = 0.306490; 	 id_w2[295] = -0.183599; 	 id_w2[296] = 0.124956; 	 id_w2[297] = 0.514640; 	 id_w2[298] = -0.255999; 	 id_w2[299] = -0.144729; 	 id_w2[300] = -0.069507; 	 id_w2[301] = 0.111432; 	 id_w2[302] = 0.195156; 	 id_w2[303] = -6.054498; 	 id_w2[304] = 0.115876; 	 id_w2[305] = -0.389804; 	 id_w2[306] = -0.146668; 	 id_w2[307] = -0.087863; 	 id_w2[308] = -0.187930; 	 id_w2[309] = 0.454334; 	 id_w2[310] = 0.270430; 	 id_w2[311] = 0.396545; 	 id_w2[312] = 0.148085; 	 id_w2[313] = 0.032273; 	 id_w2[314] = -0.227267; 	 id_w2[315] = 0.050101; 	 id_w2[316] = -0.439085; 	 id_w2[317] = -0.693663; 	 id_w2[318] = -1.471004; 	 id_w2[319] = -0.294920;
	id_w2[320] = -0.018135; 	 id_w2[321] = -0.215975; 	 id_w2[322] = -0.366049; 	 id_w2[323] = 0.046003; 	 id_w2[324] = -0.220342; 	 id_w2[325] = -0.132935; 	 id_w2[326] = 0.109920; 	 id_w2[327] = 0.018558; 	 id_w2[328] = 0.031197; 	 id_w2[329] = 0.027678; 	 id_w2[330] = -0.019972; 	 id_w2[331] = -0.001527; 	 id_w2[332] = 0.329381; 	 id_w2[333] = -0.098804; 	 id_w2[334] = 0.154709; 	 id_w2[335] = 0.038539; 	 id_w2[336] = -0.027936; 	 id_w2[337] = 0.237905; 	 id_w2[338] = 0.175700; 	 id_w2[339] = -0.086023; 	 id_w2[340] = -0.005019; 	 id_w2[341] = -0.018244; 	 id_w2[342] = 0.100264; 	 id_w2[343] = 0.063824; 	 id_w2[344] = 0.358800; 	 id_w2[345] = 0.025610; 	 id_w2[346] = 0.041473; 	 id_w2[347] = 0.088504; 	 id_w2[348] = 0.047965; 	 id_w2[349] = 0.069699; 	 id_w2[350] = 0.379391; 	 id_w2[351] = 0.056997;
	id_w2[352] = -0.162650; 	 id_w2[353] = -0.246706; 	 id_w2[354] = -0.035442; 	 id_w2[355] = 0.323164; 	 id_w2[356] = 0.487865; 	 id_w2[357] = -0.438602; 	 id_w2[358] = -0.186359; 	 id_w2[359] = 0.561696; 	 id_w2[360] = 0.400009; 	 id_w2[361] = 0.266051; 	 id_w2[362] = 0.441907; 	 id_w2[363] = 0.299897; 	 id_w2[364] = -0.306342; 	 id_w2[365] = -0.381606; 	 id_w2[366] = -0.088730; 	 id_w2[367] = 0.140200; 	 id_w2[368] = 0.201628; 	 id_w2[369] = -0.178801; 	 id_w2[370] = -0.190621; 	 id_w2[371] = -0.324836; 	 id_w2[372] = -0.720474; 	 id_w2[373] = 0.367914; 	 id_w2[374] = -0.209243; 	 id_w2[375] = 0.037381; 	 id_w2[376] = 0.024377; 	 id_w2[377] = -0.141955; 	 id_w2[378] = -0.817768; 	 id_w2[379] = -0.365834; 	 id_w2[380] = 0.222076; 	 id_w2[381] = 0.235572; 	 id_w2[382] = 0.141245; 	 id_w2[383] = 0.270281;
	id_w2[384] = 0.320788; 	 id_w2[385] = -1.089983; 	 id_w2[386] = -0.046285; 	 id_w2[387] = 1.079026; 	 id_w2[388] = 0.634462; 	 id_w2[389] = -0.435926; 	 id_w2[390] = -0.573046; 	 id_w2[391] = 0.522824; 	 id_w2[392] = 0.519437; 	 id_w2[393] = 0.619094; 	 id_w2[394] = 0.995377; 	 id_w2[395] = 0.472240; 	 id_w2[396] = -0.086168; 	 id_w2[397] = -0.264548; 	 id_w2[398] = 0.281379; 	 id_w2[399] = 0.907190; 	 id_w2[400] = 0.592900; 	 id_w2[401] = -0.076803; 	 id_w2[402] = -0.204567; 	 id_w2[403] = -0.866342; 	 id_w2[404] = -0.704150; 	 id_w2[405] = 0.461747; 	 id_w2[406] = -0.643449; 	 id_w2[407] = 0.089811; 	 id_w2[408] = 0.031089; 	 id_w2[409] = -0.545955; 	 id_w2[410] = -1.561265; 	 id_w2[411] = -0.318909; 	 id_w2[412] = 0.303546; 	 id_w2[413] = 0.495390; 	 id_w2[414] = 1.397912; 	 id_w2[415] = 0.418977;
	id_w2[416] = -0.099667; 	 id_w2[417] = 0.323028; 	 id_w2[418] = -0.182819; 	 id_w2[419] = -0.965857; 	 id_w2[420] = -0.549941; 	 id_w2[421] = 0.193902; 	 id_w2[422] = 0.729582; 	 id_w2[423] = 0.008414; 	 id_w2[424] = -0.917472; 	 id_w2[425] = -0.349779; 	 id_w2[426] = -0.992915; 	 id_w2[427] = 0.267948; 	 id_w2[428] = -1.736336; 	 id_w2[429] = 0.614670; 	 id_w2[430] = 0.367322; 	 id_w2[431] = 0.008764; 	 id_w2[432] = -0.153356; 	 id_w2[433] = 0.761933; 	 id_w2[434] = 0.099072; 	 id_w2[435] = 0.488674; 	 id_w2[436] = 2.196848; 	 id_w2[437] = -0.457890; 	 id_w2[438] = 0.751184; 	 id_w2[439] = -0.281569; 	 id_w2[440] = -0.692755; 	 id_w2[441] = 0.879105; 	 id_w2[442] = -0.128600; 	 id_w2[443] = -0.043194; 	 id_w2[444] = -0.509176; 	 id_w2[445] = -0.516687; 	 id_w2[446] = -0.314608; 	 id_w2[447] = 0.063782;
	id_w2[448] = 0.048265; 	 id_w2[449] = 0.622561; 	 id_w2[450] = -0.091263; 	 id_w2[451] = -0.684113; 	 id_w2[452] = -0.580098; 	 id_w2[453] = 0.372936; 	 id_w2[454] = 0.518205; 	 id_w2[455] = -0.299002; 	 id_w2[456] = -0.531696; 	 id_w2[457] = -0.848809; 	 id_w2[458] = -0.737954; 	 id_w2[459] = 0.083291; 	 id_w2[460] = -0.150537; 	 id_w2[461] = 0.391981; 	 id_w2[462] = -0.113580; 	 id_w2[463] = -1.720360; 	 id_w2[464] = -0.351042; 	 id_w2[465] = -0.021471; 	 id_w2[466] = -0.601360; 	 id_w2[467] = 0.681077; 	 id_w2[468] = 0.426622; 	 id_w2[469] = -0.184622; 	 id_w2[470] = 0.225478; 	 id_w2[471] = -0.250971; 	 id_w2[472] = -0.243693; 	 id_w2[473] = 0.611797; 	 id_w2[474] = 1.197800; 	 id_w2[475] = 0.255480; 	 id_w2[476] = -0.561205; 	 id_w2[477] = -0.514007; 	 id_w2[478] = -1.113735; 	 id_w2[479] = -0.142704;
	id_w2[480] = -0.086151; 	 id_w2[481] = -0.507904; 	 id_w2[482] = 0.860617; 	 id_w2[483] = 0.613823; 	 id_w2[484] = -0.013975; 	 id_w2[485] = -0.026891; 	 id_w2[486] = -0.218012; 	 id_w2[487] = 0.203450; 	 id_w2[488] = 0.016287; 	 id_w2[489] = -0.007422; 	 id_w2[490] = 0.495767; 	 id_w2[491] = 0.060043; 	 id_w2[492] = 0.230622; 	 id_w2[493] = -0.022178; 	 id_w2[494] = 0.049502; 	 id_w2[495] = 1.586623; 	 id_w2[496] = -0.035545; 	 id_w2[497] = 0.140152; 	 id_w2[498] = 0.392854; 	 id_w2[499] = -0.128025; 	 id_w2[500] = -0.252567; 	 id_w2[501] = 0.105945; 	 id_w2[502] = -0.375442; 	 id_w2[503] = -0.107640; 	 id_w2[504] = -0.173454; 	 id_w2[505] = -0.048757; 	 id_w2[506] = -0.494138; 	 id_w2[507] = -0.118787; 	 id_w2[508] = 0.215382; 	 id_w2[509] = 0.175726; 	 id_w2[510] = 0.992709; 	 id_w2[511] = 0.206766;
	// hidden layer 2 bias
	id_b2[0] = 0.806161;
	id_b2[1] = 0.619781;
	id_b2[2] = -0.609764;
	id_b2[3] = -0.182383;
	id_b2[4] = -0.307337;
	id_b2[5] = -0.645893;
	id_b2[6] = 0.028189;
	id_b2[7] = -0.335926;
	id_b2[8] = 0.090751;
	id_b2[9] = 0.460366;
	id_b2[10] = -0.113282;
	id_b2[11] = -0.283255;
	id_b2[12] = -0.410993;
	id_b2[13] = 0.403989;
	id_b2[14] = 0.168861;
	id_b2[15] = -0.273244;

	// output layer (linear)
	id_wo[0] = -0.203273;
	id_wo[1] = -0.237197;
	id_wo[2] = 0.353044;
	id_wo[3] = 0.371979;
	id_wo[4] = -0.132944;
	id_wo[5] = 0.329909;
	id_wo[6] = 0.660572;
	id_wo[7] = 0.101408;
	id_wo[8] = 0.642734;
	id_wo[9] = 0.743450;
	id_wo[10] = 0.070201;
	id_wo[11] = 0.339806;
	id_wo[12] = 0.176282;
	id_wo[13] = -0.143814;
	id_wo[14] = 0.238669;
	id_wo[15] = -0.214066;
	id_bo = -0.177045;

	// ================= CGD network =================
	cgd_y_mean = 1.228109;
	cgd_y_std  = 0.807682;

	// hidden layer 1 weights: cgd_w1[NI*i + k]
	cgd_w1[0] = 0.086930; 	 cgd_w1[1] = 0.415004; 	 cgd_w1[2] = 0.260191; 	 cgd_w1[3] = 0.781836;
	cgd_w1[4] = -1.347649; 	 cgd_w1[5] = 0.100895; 	 cgd_w1[6] = 0.069309; 	 cgd_w1[7] = 0.496920;
	cgd_w1[8] = 1.436500; 	 cgd_w1[9] = -0.366814; 	 cgd_w1[10] = 0.218206; 	 cgd_w1[11] = 0.109473;
	cgd_w1[12] = 1.341801; 	 cgd_w1[13] = 0.067715; 	 cgd_w1[14] = 0.129318; 	 cgd_w1[15] = 0.007166;
	cgd_w1[16] = 1.309605; 	 cgd_w1[17] = 0.073904; 	 cgd_w1[18] = -0.184669; 	 cgd_w1[19] = 0.185699;
	cgd_w1[20] = -1.266425; 	 cgd_w1[21] = -0.058636; 	 cgd_w1[22] = -0.230037; 	 cgd_w1[23] = 0.140892;
	cgd_w1[24] = -1.246382; 	 cgd_w1[25] = -0.230505; 	 cgd_w1[26] = 0.037281; 	 cgd_w1[27] = -0.188607;
	cgd_w1[28] = -0.939303; 	 cgd_w1[29] = -0.493840; 	 cgd_w1[30] = 0.238099; 	 cgd_w1[31] = -0.577227;
	cgd_w1[32] = 1.265597; 	 cgd_w1[33] = 0.083210; 	 cgd_w1[34] = -0.195569; 	 cgd_w1[35] = 0.285796;
	cgd_w1[36] = -0.116595; 	 cgd_w1[37] = 0.403982; 	 cgd_w1[38] = -0.010955; 	 cgd_w1[39] = -0.239610;
	cgd_w1[40] = 0.551006; 	 cgd_w1[41] = -0.135590; 	 cgd_w1[42] = -0.115180; 	 cgd_w1[43] = 0.197872;
	cgd_w1[44] = 1.258482; 	 cgd_w1[45] = -0.218586; 	 cgd_w1[46] = 0.094105; 	 cgd_w1[47] = 0.055765;
	cgd_w1[48] = 1.131386; 	 cgd_w1[49] = -0.304753; 	 cgd_w1[50] = -0.538560; 	 cgd_w1[51] = -0.277822;
	cgd_w1[52] = -1.451637; 	 cgd_w1[53] = 0.410269; 	 cgd_w1[54] = 0.252594; 	 cgd_w1[55] = 0.254975;
	cgd_w1[56] = 1.413194; 	 cgd_w1[57] = -0.008698; 	 cgd_w1[58] = 0.236354; 	 cgd_w1[59] = -0.381272;
	cgd_w1[60] = -2.093287; 	 cgd_w1[61] = -0.341270; 	 cgd_w1[62] = 0.235352; 	 cgd_w1[63] = -0.004468;
	cgd_w1[64] = 0.897607; 	 cgd_w1[65] = -0.104171; 	 cgd_w1[66] = 0.362679; 	 cgd_w1[67] = -0.191579;
	cgd_w1[68] = -1.197175; 	 cgd_w1[69] = -0.298217; 	 cgd_w1[70] = 0.459883; 	 cgd_w1[71] = 0.144091;
	// hidden layer 1 bias
	cgd_b1[0] = 1.034977;
	cgd_b1[1] = 0.268481;
	cgd_b1[2] = -0.970468;
	cgd_b1[3] = -0.797016;
	cgd_b1[4] = -0.698035;
	cgd_b1[5] = 0.687634;
	cgd_b1[6] = 0.757457;
	cgd_b1[7] = 0.740312;
	cgd_b1[8] = -0.728359;
	cgd_b1[9] = -0.405300;
	cgd_b1[10] = -0.321646;
	cgd_b1[11] = -0.796625;
	cgd_b1[12] = -0.145315;
	cgd_b1[13] = 0.427968;
	cgd_b1[14] = -0.586129;
	cgd_b1[15] = 0.933211;
	cgd_b1[16] = -0.521095;
	cgd_b1[17] = 0.390689;

	// hidden layer 2 weights: cgd_w2[CGD_NH1*i + j]
	cgd_w2[0] = -0.089360; 	 cgd_w2[1] = -0.212643; 	 cgd_w2[2] = 0.939572; 	 cgd_w2[3] = 1.075106; 	 cgd_w2[4] = 0.830764; 	 cgd_w2[5] = -0.752032; 	 cgd_w2[6] = -0.463363; 	 cgd_w2[7] = -0.842614; 	 cgd_w2[8] = 0.774647; 	 cgd_w2[9] = -0.171554; 	 cgd_w2[10] = 0.068046; 	 cgd_w2[11] = 1.022505; 	 cgd_w2[12] = 0.518917; 	 cgd_w2[13] = -0.870255; 	 cgd_w2[14] = 0.361204; 	 cgd_w2[15] = -0.670288; 	 cgd_w2[16] = 0.232136; 	 cgd_w2[17] = -0.557839;
	cgd_w2[18] = -0.180042; 	 cgd_w2[19] = -0.572234; 	 cgd_w2[20] = 1.877711; 	 cgd_w2[21] = 2.015010; 	 cgd_w2[22] = 2.261117; 	 cgd_w2[23] = -1.245952; 	 cgd_w2[24] = -1.436774; 	 cgd_w2[25] = -1.051388; 	 cgd_w2[26] = 1.853452; 	 cgd_w2[27] = -0.224871; 	 cgd_w2[28] = 0.152099; 	 cgd_w2[29] = 1.498020; 	 cgd_w2[30] = 0.935979; 	 cgd_w2[31] = -1.999517; 	 cgd_w2[32] = 0.505773; 	 cgd_w2[33] = -0.898782; 	 cgd_w2[34] = 0.484755; 	 cgd_w2[35] = -1.005262;
	cgd_w2[36] = -0.129676; 	 cgd_w2[37] = -1.036141; 	 cgd_w2[38] = 1.590677; 	 cgd_w2[39] = 1.584554; 	 cgd_w2[40] = 1.677598; 	 cgd_w2[41] = -1.268759; 	 cgd_w2[42] = -1.410326; 	 cgd_w2[43] = -0.609503; 	 cgd_w2[44] = 1.122848; 	 cgd_w2[45] = -0.075375; 	 cgd_w2[46] = 0.159476; 	 cgd_w2[47] = 1.466219; 	 cgd_w2[48] = 0.729943; 	 cgd_w2[49] = -1.650693; 	 cgd_w2[50] = 0.914946; 	 cgd_w2[51] = -1.362189; 	 cgd_w2[52] = 1.102070; 	 cgd_w2[53] = -0.717438;
	cgd_w2[54] = -0.311798; 	 cgd_w2[55] = -0.964678; 	 cgd_w2[56] = 3.294298; 	 cgd_w2[57] = 3.819361; 	 cgd_w2[58] = 3.733055; 	 cgd_w2[59] = -2.304744; 	 cgd_w2[60] = -2.353578; 	 cgd_w2[61] = -1.594132; 	 cgd_w2[62] = 2.811207; 	 cgd_w2[63] = 0.085643; 	 cgd_w2[64] = 0.472816; 	 cgd_w2[65] = 3.408041; 	 cgd_w2[66] = 1.473774; 	 cgd_w2[67] = -3.478161; 	 cgd_w2[68] = 1.357169; 	 cgd_w2[69] = -1.844172; 	 cgd_w2[70] = 1.616582; 	 cgd_w2[71] = -1.291866;
	cgd_w2[72] = -0.201835; 	 cgd_w2[73] = -0.446560; 	 cgd_w2[74] = 0.082897; 	 cgd_w2[75] = 0.034302; 	 cgd_w2[76] = -0.055413; 	 cgd_w2[77] = 0.121077; 	 cgd_w2[78] = 0.192259; 	 cgd_w2[79] = 0.313790; 	 cgd_w2[80] = -0.242363; 	 cgd_w2[81] = 0.276627; 	 cgd_w2[82] = -0.163287; 	 cgd_w2[83] = -0.163252; 	 cgd_w2[84] = 0.891698; 	 cgd_w2[85] = -0.617636; 	 cgd_w2[86] = -0.097784; 	 cgd_w2[87] = -0.021200; 	 cgd_w2[88] = 0.012430; 	 cgd_w2[89] = -0.991800;
	cgd_w2[90] = 0.288848; 	 cgd_w2[91] = 0.272555; 	 cgd_w2[92] = -1.389699; 	 cgd_w2[93] = -1.677519; 	 cgd_w2[94] = -1.537633; 	 cgd_w2[95] = 0.964825; 	 cgd_w2[96] = 1.265459; 	 cgd_w2[97] = 0.964571; 	 cgd_w2[98] = -1.533313; 	 cgd_w2[99] = -0.285948; 	 cgd_w2[100] = -0.232724; 	 cgd_w2[101] = -1.773678; 	 cgd_w2[102] = -0.725012; 	 cgd_w2[103] = 1.569262; 	 cgd_w2[104] = -0.407471; 	 cgd_w2[105] = 0.544012; 	 cgd_w2[106] = -0.584314; 	 cgd_w2[107] = 0.760671;
	cgd_w2[108] = 0.017490; 	 cgd_w2[109] = 0.435387; 	 cgd_w2[110] = -1.870456; 	 cgd_w2[111] = -2.120078; 	 cgd_w2[112] = -1.910492; 	 cgd_w2[113] = 1.001024; 	 cgd_w2[114] = 1.202630; 	 cgd_w2[115] = 0.798371; 	 cgd_w2[116] = -1.880263; 	 cgd_w2[117] = -0.177966; 	 cgd_w2[118] = -0.281412; 	 cgd_w2[119] = -1.586895; 	 cgd_w2[120] = -0.767529; 	 cgd_w2[121] = 1.903180; 	 cgd_w2[122] = -0.663033; 	 cgd_w2[123] = 0.488010; 	 cgd_w2[124] = -0.574999; 	 cgd_w2[125] = 1.053159;
	cgd_w2[126] = -0.045503; 	 cgd_w2[127] = 0.574026; 	 cgd_w2[128] = -1.129658; 	 cgd_w2[129] = -1.547615; 	 cgd_w2[130] = -0.890827; 	 cgd_w2[131] = 1.187030; 	 cgd_w2[132] = 0.486886; 	 cgd_w2[133] = -0.168378; 	 cgd_w2[134] = -0.786826; 	 cgd_w2[135] = 0.133694; 	 cgd_w2[136] = 0.148686; 	 cgd_w2[137] = -1.218831; 	 cgd_w2[138] = -0.318628; 	 cgd_w2[139] = 0.687365; 	 cgd_w2[140] = -1.010824; 	 cgd_w2[141] = 0.451492; 	 cgd_w2[142] = -0.734908; 	 cgd_w2[143] = 0.379001;
	cgd_w2[144] = 0.202811; 	 cgd_w2[145] = 0.107901; 	 cgd_w2[146] = -0.896089; 	 cgd_w2[147] = -1.214097; 	 cgd_w2[148] = -1.215305; 	 cgd_w2[149] = 0.146819; 	 cgd_w2[150] = 0.718963; 	 cgd_w2[151] = 0.223148; 	 cgd_w2[152] = -0.913415; 	 cgd_w2[153] = -0.238317; 	 cgd_w2[154] = -0.108277; 	 cgd_w2[155] = -1.013938; 	 cgd_w2[156] = -0.774302; 	 cgd_w2[157] = 0.955475; 	 cgd_w2[158] = -0.251289; 	 cgd_w2[159] = 0.373646; 	 cgd_w2[160] = -0.295629; 	 cgd_w2[161] = 0.407069;
	// hidden layer 2 bias
	cgd_b2[0] = -0.156163;
	cgd_b2[1] = -0.164349;
	cgd_b2[2] = -0.103304;
	cgd_b2[3] = -0.581469;
	cgd_b2[4] = -0.106936;
	cgd_b2[5] = 0.127861;
	cgd_b2[6] = 0.157372;
	cgd_b2[7] = 0.083964;
	cgd_b2[8] = 0.314637;

	// output layer (linear)
	cgd_wo[0] = -0.252537;
	cgd_wo[1] = 0.456199;
	cgd_wo[2] = -0.405966;
	cgd_wo[3] = 0.954539;
	cgd_wo[4] = 0.117428;
	cgd_wo[5] = 0.316338;
	cgd_wo[6] = -0.104776;
	cgd_wo[7] = -0.130789;
	cgd_wo[8] = -0.336807;
	cgd_bo = -0.073349;

	// ================= CGS network =================
	cgs_y_mean = 1.203874;
	cgs_y_std  = 0.837098;

	// hidden layer 1 weights: cgs_w1[NI*i + k]
	cgs_w1[0] = 1.108609; 	 cgs_w1[1] = 0.415004; 	 cgs_w1[2] = -0.118204; 	 cgs_w1[3] = 0.411562;
	cgs_w1[4] = -0.757525; 	 cgs_w1[5] = 0.100895; 	 cgs_w1[6] = 0.033525; 	 cgs_w1[7] = 0.311859;
	cgs_w1[8] = 2.200951; 	 cgs_w1[9] = -0.366814; 	 cgs_w1[10] = -0.037390; 	 cgs_w1[11] = -0.228565;
	cgs_w1[12] = 0.946051; 	 cgs_w1[13] = 0.067715; 	 cgs_w1[14] = 0.206225; 	 cgs_w1[15] = 0.001964;
	cgs_w1[16] = 1.259720; 	 cgs_w1[17] = 0.073904; 	 cgs_w1[18] = -0.253552; 	 cgs_w1[19] = -0.040300;
	cgs_w1[20] = -0.981301; 	 cgs_w1[21] = -0.058636; 	 cgs_w1[22] = -0.175529; 	 cgs_w1[23] = 0.338067;
	cgs_w1[24] = -1.144282; 	 cgs_w1[25] = -0.230505; 	 cgs_w1[26] = -0.053493; 	 cgs_w1[27] = -0.231480;
	cgs_w1[28] = 0.761978; 	 cgs_w1[29] = -0.493840; 	 cgs_w1[30] = 0.549397; 	 cgs_w1[31] = -0.122531;
	cgs_w1[32] = 1.032685; 	 cgs_w1[33] = 0.083210; 	 cgs_w1[34] = -0.126353; 	 cgs_w1[35] = 0.361403;
	cgs_w1[36] = 0.952849; 	 cgs_w1[37] = 0.403982; 	 cgs_w1[38] = -0.001029; 	 cgs_w1[39] = -0.169045;
	cgs_w1[40] = 0.973425; 	 cgs_w1[41] = -0.135590; 	 cgs_w1[42] = -0.000282; 	 cgs_w1[43] = 0.261928;
	cgs_w1[44] = 1.013000; 	 cgs_w1[45] = -0.218586; 	 cgs_w1[46] = 0.193048; 	 cgs_w1[47] = 0.029838;
	cgs_w1[48] = 1.169015; 	 cgs_w1[49] = -0.304753; 	 cgs_w1[50] = -0.379780; 	 cgs_w1[51] = -0.230034;
	cgs_w1[52] = -1.295827; 	 cgs_w1[53] = 0.410269; 	 cgs_w1[54] = 0.051179; 	 cgs_w1[55] = 0.013686;
	cgs_w1[56] = 0.412684; 	 cgs_w1[57] = -0.008698; 	 cgs_w1[58] = 0.395951; 	 cgs_w1[59] = 0.037851;
	cgs_w1[60] = -1.390174; 	 cgs_w1[61] = -0.341270; 	 cgs_w1[62] = 0.113307; 	 cgs_w1[63] = -0.038304;
	cgs_w1[64] = -0.479090; 	 cgs_w1[65] = -0.104171; 	 cgs_w1[66] = 0.136322; 	 cgs_w1[67] = -0.576144;
	cgs_w1[68] = -1.030163; 	 cgs_w1[69] = -0.298217; 	 cgs_w1[70] = 0.371602; 	 cgs_w1[71] = 0.157299;
	cgs_w1[72] = 1.443650; 	 cgs_w1[73] = -0.412638; 	 cgs_w1[74] = -0.383900; 	 cgs_w1[75] = -0.240177;
	cgs_w1[76] = -1.217050; 	 cgs_w1[77] = 0.202520; 	 cgs_w1[78] = 0.201623; 	 cgs_w1[79] = 0.490783;
	// hidden layer 1 bias
	cgs_b1[0] = -0.801388;
	cgs_b1[1] = 0.237252;
	cgs_b1[2] = -0.999765;
	cgs_b1[3] = -0.639607;
	cgs_b1[4] = -0.473806;
	cgs_b1[5] = 0.329542;
	cgs_b1[6] = 0.815738;
	cgs_b1[7] = -0.779785;
	cgs_b1[8] = -0.706797;
	cgs_b1[9] = -0.445666;
	cgs_b1[10] = -0.773882;
	cgs_b1[11] = -0.646496;
	cgs_b1[12] = -0.237557;
	cgs_b1[13] = 0.672546;
	cgs_b1[14] = -0.710314;
	cgs_b1[15] = 0.715998;
	cgs_b1[16] = 0.630438;
	cgs_b1[17] = 0.194916;
	cgs_b1[18] = -0.456633;
	cgs_b1[19] = 0.125486;

	// hidden layer 2 weights: cgs_w2[CGS_NH1*i + j]
	cgs_w2[0] = 0.400328; 	 cgs_w2[1] = 0.317158; 	 cgs_w2[2] = -0.050286; 	 cgs_w2[3] = 0.300626; 	 cgs_w2[4] = -0.100242; 	 cgs_w2[5] = -0.288660; 	 cgs_w2[6] = -0.822921; 	 cgs_w2[7] = -0.084475; 	 cgs_w2[8] = 0.315756; 	 cgs_w2[9] = -0.259975; 	 cgs_w2[10] = 0.401569; 	 cgs_w2[11] = 0.485371; 	 cgs_w2[12] = -0.256344; 	 cgs_w2[13] = -0.312912; 	 cgs_w2[14] = -0.008886; 	 cgs_w2[15] = 0.047036; 	 cgs_w2[16] = -0.131087; 	 cgs_w2[17] = 0.049956; 	 cgs_w2[18] = -0.097511; 	 cgs_w2[19] = 0.313360;
	cgs_w2[20] = 0.244085; 	 cgs_w2[21] = -0.205696; 	 cgs_w2[22] = -0.157196; 	 cgs_w2[23] = 0.113620; 	 cgs_w2[24] = 0.137316; 	 cgs_w2[25] = -0.578840; 	 cgs_w2[26] = -0.256945; 	 cgs_w2[27] = -0.300628; 	 cgs_w2[28] = 0.646941; 	 cgs_w2[29] = 0.202183; 	 cgs_w2[30] = -0.079902; 	 cgs_w2[31] = 0.370760; 	 cgs_w2[32] = 0.157212; 	 cgs_w2[33] = 0.060605; 	 cgs_w2[34] = -0.314207; 	 cgs_w2[35] = 0.047309; 	 cgs_w2[36] = -0.031156; 	 cgs_w2[37] = -0.671355; 	 cgs_w2[38] = 0.044983; 	 cgs_w2[39] = -0.806627;
	cgs_w2[40] = 0.083548; 	 cgs_w2[41] = 0.135808; 	 cgs_w2[42] = 0.051196; 	 cgs_w2[43] = -0.097939; 	 cgs_w2[44] = -0.048856; 	 cgs_w2[45] = 0.038415; 	 cgs_w2[46] = 0.294871; 	 cgs_w2[47] = 0.676394; 	 cgs_w2[48] = 0.259611; 	 cgs_w2[49] = -0.153356; 	 cgs_w2[50] = 0.118395; 	 cgs_w2[51] = -0.159546; 	 cgs_w2[52] = -0.307810; 	 cgs_w2[53] = -0.044639; 	 cgs_w2[54] = 0.420811; 	 cgs_w2[55] = -0.211816; 	 cgs_w2[56] = -0.248712; 	 cgs_w2[57] = 0.332597; 	 cgs_w2[58] = -0.477479; 	 cgs_w2[59] = 0.087916;
	cgs_w2[60] = 3.261299; 	 cgs_w2[61] = -0.339834; 	 cgs_w2[62] = 3.538250; 	 cgs_w2[63] = 2.284547; 	 cgs_w2[64] = 1.851440; 	 cgs_w2[65] = -1.317815; 	 cgs_w2[66] = -3.927691; 	 cgs_w2[67] = 0.991500; 	 cgs_w2[68] = 3.206985; 	 cgs_w2[69] = 1.811652; 	 cgs_w2[70] = 1.888277; 	 cgs_w2[71] = 2.043743; 	 cgs_w2[72] = 1.325050; 	 cgs_w2[73] = -3.435655; 	 cgs_w2[74] = 0.310884; 	 cgs_w2[75] = -3.260578; 	 cgs_w2[76] = -0.600576; 	 cgs_w2[77] = -1.229241; 	 cgs_w2[78] = 1.321387; 	 cgs_w2[79] = -1.792181;
	cgs_w2[80] = 0.256496; 	 cgs_w2[81] = 0.269961; 	 cgs_w2[82] = -0.020329; 	 cgs_w2[83] = 0.057888; 	 cgs_w2[84] = 0.129449; 	 cgs_w2[85] = -0.002659; 	 cgs_w2[86] = -0.066403; 	 cgs_w2[87] = 0.025003; 	 cgs_w2[88] = 0.161375; 	 cgs_w2[89] = -0.060270; 	 cgs_w2[90] = 0.006623; 	 cgs_w2[91] = 0.079884; 	 cgs_w2[92] = -0.105098; 	 cgs_w2[93] = 0.201050; 	 cgs_w2[94] = 0.024058; 	 cgs_w2[95] = 0.054577; 	 cgs_w2[96] = -0.106884; 	 cgs_w2[97] = 0.147562; 	 cgs_w2[98] = -0.138860; 	 cgs_w2[99] = 0.234957;
	cgs_w2[100] = 0.577919; 	 cgs_w2[101] = -0.068745; 	 cgs_w2[102] = 0.637843; 	 cgs_w2[103] = 0.848458; 	 cgs_w2[104] = 0.286251; 	 cgs_w2[105] = -0.504243; 	 cgs_w2[106] = -1.050688; 	 cgs_w2[107] = -0.005561; 	 cgs_w2[108] = 0.813794; 	 cgs_w2[109] = 0.541828; 	 cgs_w2[110] = 0.455546; 	 cgs_w2[111] = 0.698255; 	 cgs_w2[112] = 0.127856; 	 cgs_w2[113] = -0.676570; 	 cgs_w2[114] = 0.189525; 	 cgs_w2[115] = -0.053382; 	 cgs_w2[116] = -0.246446; 	 cgs_w2[117] = -0.436789; 	 cgs_w2[118] = 0.452846; 	 cgs_w2[119] = -0.362775;
	cgs_w2[120] = -1.345106; 	 cgs_w2[121] = 0.522157; 	 cgs_w2[122] = -0.941954; 	 cgs_w2[123] = -1.198031; 	 cgs_w2[124] = -1.285877; 	 cgs_w2[125] = 0.827033; 	 cgs_w2[126] = 1.685825; 	 cgs_w2[127] = -0.619560; 	 cgs_w2[128] = -1.460156; 	 cgs_w2[129] = -1.941762; 	 cgs_w2[130] = -2.044655; 	 cgs_w2[131] = -0.684568; 	 cgs_w2[132] = -0.953030; 	 cgs_w2[133] = 1.686745; 	 cgs_w2[134] = -0.449464; 	 cgs_w2[135] = 1.959414; 	 cgs_w2[136] = 0.763223; 	 cgs_w2[137] = 0.756510; 	 cgs_w2[138] = -0.608541; 	 cgs_w2[139] = 0.990489;
	cgs_w2[140] = 0.706218; 	 cgs_w2[141] = -0.320810; 	 cgs_w2[142] = 0.819331; 	 cgs_w2[143] = 0.303141; 	 cgs_w2[144] = 0.273728; 	 cgs_w2[145] = -0.389466; 	 cgs_w2[146] = -0.936666; 	 cgs_w2[147] = 0.068510; 	 cgs_w2[148] = 0.509829; 	 cgs_w2[149] = 0.458492; 	 cgs_w2[150] = 0.293011; 	 cgs_w2[151] = 0.242734; 	 cgs_w2[152] = 0.292870; 	 cgs_w2[153] = -0.795345; 	 cgs_w2[154] = 0.001862; 	 cgs_w2[155] = -0.636142; 	 cgs_w2[156] = 0.244395; 	 cgs_w2[157] = -0.521840; 	 cgs_w2[158] = 0.565804; 	 cgs_w2[159] = -0.135801;
	cgs_w2[160] = -0.162032; 	 cgs_w2[161] = -0.347645; 	 cgs_w2[162] = 0.222319; 	 cgs_w2[163] = -0.153633; 	 cgs_w2[164] = 0.060643; 	 cgs_w2[165] = 0.074953; 	 cgs_w2[166] = 0.137311; 	 cgs_w2[167] = -0.081461; 	 cgs_w2[168] = -0.422959; 	 cgs_w2[169] = 0.006323; 	 cgs_w2[170] = 0.087805; 	 cgs_w2[171] = -0.253680; 	 cgs_w2[172] = 0.294761; 	 cgs_w2[173] = 0.202261; 	 cgs_w2[174] = 0.199330; 	 cgs_w2[175] = -0.166723; 	 cgs_w2[176] = 0.098018; 	 cgs_w2[177] = 0.017759; 	 cgs_w2[178] = 0.253821; 	 cgs_w2[179] = -0.542649;
	cgs_w2[180] = 0.894027; 	 cgs_w2[181] = -0.204492; 	 cgs_w2[182] = 0.653733; 	 cgs_w2[183] = 0.864533; 	 cgs_w2[184] = 0.260621; 	 cgs_w2[185] = -0.654253; 	 cgs_w2[186] = -1.339676; 	 cgs_w2[187] = 0.298107; 	 cgs_w2[188] = 1.254317; 	 cgs_w2[189] = 0.455124; 	 cgs_w2[190] = 0.192830; 	 cgs_w2[191] = 0.716496; 	 cgs_w2[192] = 0.172045; 	 cgs_w2[193] = -0.739675; 	 cgs_w2[194] = 0.183506; 	 cgs_w2[195] = -0.316189; 	 cgs_w2[196] = -0.136065; 	 cgs_w2[197] = -0.511809; 	 cgs_w2[198] = 0.316617; 	 cgs_w2[199] = -0.517793;
	// hidden layer 2 bias
	cgs_b2[0] = -0.015123;
	cgs_b2[1] = 0.279247;
	cgs_b2[2] = -0.052806;
	cgs_b2[3] = -0.505101;
	cgs_b2[4] = -0.080026;
	cgs_b2[5] = -0.065491;
	cgs_b2[6] = -0.028864;
	cgs_b2[7] = -0.244373;
	cgs_b2[8] = 0.105705;
	cgs_b2[9] = -0.090347;

	// output layer (linear)
	cgs_wo[0] = 0.105840;
	cgs_wo[1] = -0.175267;
	cgs_wo[2] = -0.177161;
	cgs_wo[3] = 1.345023;
	cgs_wo[4] = -0.044810;
	cgs_wo[5] = 0.026588;
	cgs_wo[6] = 0.670061;
	cgs_wo[7] = 0.319726;
	cgs_wo[8] = 0.072033;
	cgs_wo[9] = 0.049502;
	cgs_bo = -0.113958;

	end // end of initialization

	// ==== shared preprocessing: min-max to [0,1], clamped to training range ====
	vg_s = (V(G,S) - vg_lo) / (vg_hi - vg_lo);
	if (vg_s < 0) vg_s = 0;
	if (vg_s > 1) vg_s = 1;

	vd_s = (V(D,S) - vd_lo) / (vd_hi - vd_lo);
	if (vd_s < 0) vd_s = 0;
	if (vd_s > 1) vd_s = 1;

	width_s = (w - w_lo) / (w_hi - w_lo);
	if (width_s < 0) width_s = 0;
	if (width_s > 1) width_s = 1;

	length_s = (l - l_lo) / (l_hi - l_lo);
	if (length_s < 0) length_s = 0;
	if (length_s > 1) length_s = 1;

	// ================= ID: forward pass =================
	for (i = 0; i < ID_NH1; i = i + 1) begin
		id_v1[i] = vg_s*id_w1[NI*i] + vd_s*id_w1[NI*i+1]
		         + width_s*id_w1[NI*i+2] + length_s*id_w1[NI*i+3] + id_b1[i];
		id_y1[i] = tanh(id_v1[i]);
	end

	for (i = 0; i < ID_NH2; i = i + 1) begin
		id_v2[i] = 0;
		for (j = 0; j < ID_NH1; j = j + 1) begin
			id_v2[i] = id_v2[i] + id_y1[j]*id_w2[ID_NH1*i+j];
		end
		id_v2[i] = id_v2[i] + id_b2[i];
		id_y2[i] = tanh(id_v2[i]);
	end

	id_out = 0;
	for (i = 0; i < ID_NH2; i = i + 1) begin
		id_out = id_out + id_y2[i]*id_wo[i];
	end
	id_out = id_out + id_bo;

	log_id = id_out*id_y_std + id_y_mean;   // linear output, then de-standardise
	id = pow(10.0, log_id);

	// analytic small-signal conductances (chain rule through both tanh layers)
	dvg = 0;
	dvd = 0;
	for (i = 0; i < ID_NH2; i = i + 1) begin
		s_vg = 0;
		s_vd = 0;
		for (j = 0; j < ID_NH1; j = j + 1) begin
			s_vg = s_vg + id_w2[ID_NH1*i+j]*(1 - id_y1[j]*id_y1[j])*id_w1[NI*j];
			s_vd = s_vd + id_w2[ID_NH1*i+j]*(1 - id_y1[j]*id_y1[j])*id_w1[NI*j+1];
		end
		dvg = dvg + id_wo[i]*(1 - id_y2[i]*id_y2[i])*s_vg;
		dvd = dvd + id_wo[i]*(1 - id_y2[i]*id_y2[i])*s_vd;
	end
	gm  = id * `M_LN10 * id_y_std * dvg / (vg_hi - vg_lo);
	gds = id * `M_LN10 * id_y_std * dvd / (vd_hi - vd_lo);

	// ================= CGD: forward pass =================
	for (i = 0; i < CGD_NH1; i = i + 1) begin
		cgd_y1[i] = tanh(vg_s*cgd_w1[NI*i] + vd_s*cgd_w1[NI*i+1]
		                 + width_s*cgd_w1[NI*i+2] + length_s*cgd_w1[NI*i+3] + cgd_b1[i]);
	end
	for (i = 0; i < CGD_NH2; i = i + 1) begin
		cgd_acc = 0;
		for (j = 0; j < CGD_NH1; j = j + 1) begin
			cgd_acc = cgd_acc + cgd_y1[j]*cgd_w2[CGD_NH1*i+j];
		end
		cgd_y2[i] = tanh(cgd_acc + cgd_b2[i]);
	end
	cgd_out = 0;
	for (i = 0; i < CGD_NH2; i = i + 1) begin
		cgd_out = cgd_out + cgd_y2[i]*cgd_wo[i];
	end
	cgd_out = cgd_out + cgd_bo;
	cgd = (cgd_out*cgd_y_std + cgd_y_mean);   // C/(W*L) in pF/um^2 * 1e3
	cgd = cgd * (w*1.0e6) * (l*1.0e6) * 1.0e-3;   // -> pF (re-apply gate area)
	cgd = cgd * 1.0e-12;   // pF -> F
	if (cgd < 0) cgd = 0;   // floor: reject small sub-zero extrapolation excursions

	// ================= CGS: forward pass =================
	for (i = 0; i < CGS_NH1; i = i + 1) begin
		cgs_y1[i] = tanh(vg_s*cgs_w1[NI*i] + vd_s*cgs_w1[NI*i+1]
		                 + width_s*cgs_w1[NI*i+2] + length_s*cgs_w1[NI*i+3] + cgs_b1[i]);
	end
	for (i = 0; i < CGS_NH2; i = i + 1) begin
		cgs_acc = 0;
		for (j = 0; j < CGS_NH1; j = j + 1) begin
			cgs_acc = cgs_acc + cgs_y1[j]*cgs_w2[CGS_NH1*i+j];
		end
		cgs_y2[i] = tanh(cgs_acc + cgs_b2[i]);
	end
	cgs_out = 0;
	for (i = 0; i < CGS_NH2; i = i + 1) begin
		cgs_out = cgs_out + cgs_y2[i]*cgs_wo[i];
	end
	cgs_out = cgs_out + cgs_bo;
	cgs = (cgs_out*cgs_y_std + cgs_y_mean);   // C/(W*L) in pF/um^2 * 1e3
	cgs = cgs * (w*1.0e6) * (l*1.0e6) * 1.0e-3;   // -> pF (re-apply gate area)
	cgs = cgs * 1.0e-12;   // pF -> F
	if (cgs < 0) cgs = 0;   // floor: reject small sub-zero extrapolation excursions

	// ================= equivalent circuit =================
	// ID as a current source across D-S; CGD, CGS as bias-dependent capacitors
	// driven as charge sources so the branch currents stay charge-conserving.
	qgd = cgd * V(G,D);
	qgs = cgs * V(G,S);

	I(D,S) <+ id;
	I(G,D) <+ ddt(qgd);
	I(G,S) <+ ddt(qgs);

	end

endmodule
