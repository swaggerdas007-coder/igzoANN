// VerilogA for a-IGZO TFT ANN FULL model -- ID + CGD + CGS, three separate
// ANNs joined per the equivalent circuit of Bahubalindruni et al., "InGaZnO
// TFT behavioral model for IC design", Analog Integr Circ Sig Process
// (2016) 87:73-80, Fig. 1(b) ("Each electrical element in the EC is
// modeled with an ANN... these ANNs are connected together as per the EC").
//
// ID block: MLP, 32 tanh hidden neurons -> linear output, on
// (VG, VD, W, L) -> log10(|ID|), architecture and pre/post-processing
// identical to tft_ann_static.va (see that file / export_verilog_a.py for
// the full rationale).
//
// CGD, CGS blocks: PER-DEVICE MLPs, 8 tanh hidden neurons -> linear
// output, on VG ALONE -> capacitance in farads. One subnetwork per measured
// (W, L) geometry -- (20,20), (40,20), (160,15), (160,20) um -- selected by nearest match at
// initial_step (device parameters w, l are fixed per instance, so this is
// zero runtime cost), the same pattern tft_ann_static_per_L.va uses for L.
// A combined (VG, W, L) capacitance network was tried first
// (src/train_cap.py) but visibly misplaced each device's turn-on knee with
// only 4 geometry points to interpolate from -- see
// outputs_cap/plots/cgd_cgs_ann_fit.png vs. cgd_cgs_ann_fit_per_device.png.
//
// *** CAVEAT *** CGD and CGS have NO VDS DEPENDENCE. The underlying C-V
// measurements (data_cv_cleaned/) were taken at a single fixed VDS = 0 V
// bias -- the paper's own CGSi/CGDi model additionally depends on VDS and
// captures the saturation-region asymmetry (CGDi -> 0, CGSi -> 2/3 CCH,
// paper Fig. 5/6); this module cannot reproduce that. CGD(VG) and CGS(VG)
// here are each applied as a bias-dependent (in VG only) capacitor, driven
// as a charge source I <+ ddt(C*V) for a well-posed capacitive branch
// current. Also, geometry support is only the 4 measured (W,L) points
// (nearest-match, not interpolated) vs. the ID model's continuous (W,L)
// interpolation over 19 geometries. See data_cv_cleaned/README.md.
//
// Auto-generated by scripts/export_verilog_a_full.py from outputs/weights.json,
// outputs_cap/per_device/weights_{cgd,cgs}_W{W}_L{L}.json.
// Do not hand-edit the weight/bias tables -- regenerate instead.

`include "constants.h"
`include "disciplines.h"

module tft_ann_full_model(D, G, S);
inout G, D, S;
electrical D, G, S;

parameter integer NI = 4;      // ID inputs: VG, VD, W, L
parameter integer NNHL = 32;    // ID hidden neurons
parameter integer NO = 1;
parameter integer CAP_NNHL = 8;   // CGD/CGS per-device hidden neurons

// device geometry (SI units, matching Spectre convention)
parameter real w = 40e-6 from [5e-6:160e-6];  // channel width, ID training range [5,160] um
parameter real l = 20e-6 from [5e-6:20e-6];  // channel length, ID training range [5,20] um
// NOTE: CGD/CGS only support the 4 measured (W,L) points above by
// nearest match -- (20,20), (40,20), (160,15), (160,20) um -- regardless of w/l elsewhere in range.

// ---- ID block ----
real hlayer_w[0:(NI*NNHL)-1];
real hlayer_b[0:NNHL-1];
real hlayer_y[0:NNHL-1];
real hlayer_v[0:NNHL-1];
real olayer_w[0:NNHL-1];
real olayer_b;
real vg_s, vd_s, width_s, length_s;
real log_id, id, olayer_v;
real gm, gds, temp, temp1;
real vg_lo, vg_hi, vd_lo, vd_hi, w_lo, w_hi, l_lo, l_hi;
real y_mean, y_std;

// ---- CGD / CGS blocks (per-device, VG-only) ----
real cgd_hlayer_w[0:CAP_NNHL-1];
real cgd_hlayer_b[0:CAP_NNHL-1];
real cgd_hlayer_y[0:CAP_NNHL-1];
real cgd_olayer_w[0:CAP_NNHL-1];
real cgd_olayer_b;
real cgd_c_mean, cgd_c_std;
real cgd_dist, cgd_best_dist;
integer cgd_dev_sel;

real cgs_hlayer_w[0:CAP_NNHL-1];
real cgs_hlayer_b[0:CAP_NNHL-1];
real cgs_hlayer_y[0:CAP_NNHL-1];
real cgs_olayer_w[0:CAP_NNHL-1];
real cgs_olayer_b;
real cgs_c_mean, cgs_c_std;
real cgs_dist, cgs_best_dist;
integer cgs_dev_sel;

real cap_vg_lo, cap_vg_hi;
real vgc_s;
real cgd, cgs, cgd_out, cgs_out;
real qgd, qgs;
integer i, ii, jj;

analog begin
	@(initial_step or initial_step("static")) begin

	vg_lo = -5.000000; vg_hi = 5.000000;
	vd_lo = 0.000000; vd_hi = 5.000000;
	w_lo  = 5.0e-6; w_hi  = 160.0e-6;
	l_lo  = 5.0e-6; l_hi  = 20.0e-6;
	cap_vg_lo = -3.000000; cap_vg_hi = 5.000000;

	y_mean = -8.942054;
	y_std  = 3.061316;

	// ID hidden layer weights: hlayer_w[NI*i + k], k in {0:VG, 1:VD, 2:W, 3:L}
	hlayer_w[0] = 0.788857; 	 hlayer_w[1] = 2.209924; 	 hlayer_w[2] = 0.189252; 	 hlayer_w[3] = 0.185657;
	hlayer_w[4] = 2.034468; 	 hlayer_w[5] = 0.006883; 	 hlayer_w[6] = 0.734144; 	 hlayer_w[7] = 1.005106;
	hlayer_w[8] = -1.252980; 	 hlayer_w[9] = -0.003150; 	 hlayer_w[10] = 7.058150; 	 hlayer_w[11] = -1.239817;
	hlayer_w[12] = -0.000734; 	 hlayer_w[13] = 0.000107; 	 hlayer_w[14] = 0.000606; 	 hlayer_w[15] = -0.000435;
	hlayer_w[16] = 3.087128; 	 hlayer_w[17] = 0.810857; 	 hlayer_w[18] = 0.366765; 	 hlayer_w[19] = 0.160909;
	hlayer_w[20] = -3.652180; 	 hlayer_w[21] = 0.046654; 	 hlayer_w[22] = 1.128783; 	 hlayer_w[23] = -0.128095;
	hlayer_w[24] = -0.001928; 	 hlayer_w[25] = -0.000248; 	 hlayer_w[26] = 0.000847; 	 hlayer_w[27] = -0.001432;
	hlayer_w[28] = 0.203540; 	 hlayer_w[29] = -0.789309; 	 hlayer_w[30] = 0.304840; 	 hlayer_w[31] = -0.546581;
	hlayer_w[32] = 8.515797; 	 hlayer_w[33] = -0.155373; 	 hlayer_w[34] = 0.706499; 	 hlayer_w[35] = 0.393668;
	hlayer_w[36] = -0.199831; 	 hlayer_w[37] = 1.309524; 	 hlayer_w[38] = 0.082208; 	 hlayer_w[39] = -0.072819;
	hlayer_w[40] = 0.000070; 	 hlayer_w[41] = 0.000075; 	 hlayer_w[42] = 0.000285; 	 hlayer_w[43] = -0.000267;
	hlayer_w[44] = 2.887900; 	 hlayer_w[45] = 0.085982; 	 hlayer_w[46] = -0.863173; 	 hlayer_w[47] = -0.422194;
	hlayer_w[48] = -0.799702; 	 hlayer_w[49] = -2.033563; 	 hlayer_w[50] = -0.214980; 	 hlayer_w[51] = -0.024196;
	hlayer_w[52] = -0.612445; 	 hlayer_w[53] = 0.028216; 	 hlayer_w[54] = -1.246456; 	 hlayer_w[55] = 4.481590;
	hlayer_w[56] = -1.846316; 	 hlayer_w[57] = 0.593455; 	 hlayer_w[58] = -0.015660; 	 hlayer_w[59] = -0.136422;
	hlayer_w[60] = 1.544701; 	 hlayer_w[61] = -65.254105; 	 hlayer_w[62] = 0.270048; 	 hlayer_w[63] = 0.240661;
	hlayer_w[64] = -0.001414; 	 hlayer_w[65] = -0.000264; 	 hlayer_w[66] = 0.000606; 	 hlayer_w[67] = -0.001722;
	hlayer_w[68] = 0.482852; 	 hlayer_w[69] = 0.021466; 	 hlayer_w[70] = 9.384650; 	 hlayer_w[71] = 1.579896;
	hlayer_w[72] = 0.677561; 	 hlayer_w[73] = 0.018059; 	 hlayer_w[74] = -1.471672; 	 hlayer_w[75] = -2.505232;
	hlayer_w[76] = -0.520533; 	 hlayer_w[77] = -0.054476; 	 hlayer_w[78] = -0.169528; 	 hlayer_w[79] = 1.258902;
	hlayer_w[80] = -3.437316; 	 hlayer_w[81] = -0.282167; 	 hlayer_w[82] = -0.344066; 	 hlayer_w[83] = -0.234239;
	hlayer_w[84] = 2.404216; 	 hlayer_w[85] = -0.133015; 	 hlayer_w[86] = -1.200789; 	 hlayer_w[87] = 0.329707;
	hlayer_w[88] = -4.318386; 	 hlayer_w[89] = 0.016416; 	 hlayer_w[90] = 5.207554; 	 hlayer_w[91] = 0.597892;
	hlayer_w[92] = 0.363460; 	 hlayer_w[93] = 0.347618; 	 hlayer_w[94] = -0.763342; 	 hlayer_w[95] = -0.021024;
	hlayer_w[96] = 0.860451; 	 hlayer_w[97] = -0.022541; 	 hlayer_w[98] = 1.251469; 	 hlayer_w[99] = -1.159296;
	hlayer_w[100] = 0.001602; 	 hlayer_w[101] = -0.000164; 	 hlayer_w[102] = 0.000246; 	 hlayer_w[103] = 0.001881;
	hlayer_w[104] = -0.227771; 	 hlayer_w[105] = 0.005057; 	 hlayer_w[106] = -1.268210; 	 hlayer_w[107] = -0.864729;
	hlayer_w[108] = -1.462312; 	 hlayer_w[109] = 0.004300; 	 hlayer_w[110] = 6.622401; 	 hlayer_w[111] = -0.058476;
	hlayer_w[112] = 1.193326; 	 hlayer_w[113] = -0.009086; 	 hlayer_w[114] = -3.286902; 	 hlayer_w[115] = 1.668240;
	hlayer_w[116] = 3.827969; 	 hlayer_w[117] = -0.044249; 	 hlayer_w[118] = -2.301499; 	 hlayer_w[119] = 0.267389;
	hlayer_w[120] = -0.527665; 	 hlayer_w[121] = 0.267212; 	 hlayer_w[122] = 0.746527; 	 hlayer_w[123] = 0.758779;
	hlayer_w[124] = -0.001703; 	 hlayer_w[125] = -0.000549; 	 hlayer_w[126] = 0.000682; 	 hlayer_w[127] = -0.002664;

	// ID hidden layer bias
	hlayer_b[0] = 0.913660;
	hlayer_b[1] = -1.586235;
	hlayer_b[2] = 0.095963;
	hlayer_b[3] = 0.000112;
	hlayer_b[4] = -2.503599;
	hlayer_b[5] = 3.024457;
	hlayer_b[6] = 0.001436;
	hlayer_b[7] = -0.325730;
	hlayer_b[8] = -5.288231;
	hlayer_b[9] = -0.148914;
	hlayer_b[10] = -0.000102;
	hlayer_b[11] = -0.041261;
	hlayer_b[12] = 0.699486;
	hlayer_b[13] = -0.384560;
	hlayer_b[14] = 1.851819;
	hlayer_b[15] = -1.290216;
	hlayer_b[16] = 0.001098;
	hlayer_b[17] = -1.563023;
	hlayer_b[18] = -0.539663;
	hlayer_b[19] = 0.491972;
	hlayer_b[20] = 2.142080;
	hlayer_b[21] = -1.920079;
	hlayer_b[22] = 2.684408;
	hlayer_b[23] = 0.028959;
	hlayer_b[24] = -0.606180;
	hlayer_b[25] = -0.001280;
	hlayer_b[26] = 1.044605;
	hlayer_b[27] = -0.024463;
	hlayer_b[28] = -0.722012;
	hlayer_b[29] = -2.219025;
	hlayer_b[30] = 0.897722;
	hlayer_b[31] = 0.001694;

	// ID output layer weights
	olayer_w[0] = 0.191463;
	olayer_w[1] = 0.702611;
	olayer_w[2] = 1.043523;
	olayer_w[3] = -0.000015;
	olayer_w[4] = 0.970621;
	olayer_w[5] = -1.135900;
	olayer_w[6] = 0.000069;
	olayer_w[7] = 0.131407;
	olayer_w[8] = 1.545210;
	olayer_w[9] = -0.312631;
	olayer_w[10] = -0.000048;
	olayer_w[11] = -0.408185;
	olayer_w[12] = -0.190738;
	olayer_w[13] = 0.315844;
	olayer_w[14] = 0.518516;
	olayer_w[15] = -0.648074;
	olayer_w[16] = -0.000007;
	olayer_w[17] = 0.490034;
	olayer_w[18] = 0.483614;
	olayer_w[19] = -0.283802;
	olayer_w[20] = 1.634995;
	olayer_w[21] = 0.950316;
	olayer_w[22] = 1.240070;
	olayer_w[23] = 0.180198;
	olayer_w[24] = 0.631098;
	olayer_w[25] = 0.000020;
	olayer_w[26] = 0.729317;
	olayer_w[27] = -1.571019;
	olayer_w[28] = 0.581792;
	olayer_w[29] = -1.442203;
	olayer_w[30] = -0.180898;
	olayer_w[31] = -0.000015;

	// ID output layer bias
	olayer_b = 0.000051;

	// nearest-match device selection for cgd (device parameters w, l are fixed per instance)
	cgd_best_dist = 1.0e30;
	cgd_dist = pow((w - 20.0e-6)/(160.0e-6-20.0e-6), 2) + pow((l - 20.0e-6)/(20.0e-6-15.0e-6), 2);
	if (cgd_dist < cgd_best_dist) begin cgd_best_dist = cgd_dist; cgd_dev_sel = 0; end
	cgd_dist = pow((w - 40.0e-6)/(160.0e-6-20.0e-6), 2) + pow((l - 20.0e-6)/(20.0e-6-15.0e-6), 2);
	if (cgd_dist < cgd_best_dist) begin cgd_best_dist = cgd_dist; cgd_dev_sel = 1; end
	cgd_dist = pow((w - 160.0e-6)/(160.0e-6-20.0e-6), 2) + pow((l - 15.0e-6)/(20.0e-6-15.0e-6), 2);
	if (cgd_dist < cgd_best_dist) begin cgd_best_dist = cgd_dist; cgd_dev_sel = 2; end
	cgd_dist = pow((w - 160.0e-6)/(160.0e-6-20.0e-6), 2) + pow((l - 20.0e-6)/(20.0e-6-15.0e-6), 2);
	if (cgd_dist < cgd_best_dist) begin cgd_best_dist = cgd_dist; cgd_dev_sel = 3; end
	if (cgd_dev_sel == 0) begin // W=20 L=20 um
		cgd_hlayer_w[0] = 18.991402; 	 cgd_hlayer_w[1] = 0.749583; 	 cgd_hlayer_w[2] = 1.743809; 	 cgd_hlayer_w[3] = -1.451125; 	 cgd_hlayer_w[4] = -2.583515; 	 cgd_hlayer_w[5] = 0.287343; 	 cgd_hlayer_w[6] = 1.395623; 	 cgd_hlayer_w[7] = -12.229980;
		cgd_hlayer_b[0] = -7.799635;
		cgd_hlayer_b[1] = -0.598179;
		cgd_hlayer_b[2] = -0.537048;
		cgd_hlayer_b[3] = 0.290718;
		cgd_hlayer_b[4] = -0.493511;
		cgd_hlayer_b[5] = 0.790620;
		cgd_hlayer_b[6] = -0.304953;
		cgd_hlayer_b[7] = 4.907038;
		cgd_olayer_w[0] = 2.191297;
		cgd_olayer_w[1] = -0.474588;
		cgd_olayer_w[2] = 0.538655;
		cgd_olayer_w[3] = -0.431974;
		cgd_olayer_w[4] = 0.519529;
		cgd_olayer_w[5] = -0.296524;
		cgd_olayer_w[6] = 0.009909;
		cgd_olayer_w[7] = 1.379055;
		cgd_olayer_b = 0.156863;
		cgd_c_mean = 5.041065e-13;
		cgd_c_std  = 3.255314e-13;
	end
	if (cgd_dev_sel == 1) begin // W=40 L=20 um
		cgd_hlayer_w[0] = -0.674732; 	 cgd_hlayer_w[1] = 0.041858; 	 cgd_hlayer_w[2] = 0.553123; 	 cgd_hlayer_w[3] = 0.660393; 	 cgd_hlayer_w[4] = 21.570562; 	 cgd_hlayer_w[5] = -1.679823; 	 cgd_hlayer_w[6] = -3.009449; 	 cgd_hlayer_w[7] = -8.617292;
		cgd_hlayer_b[0] = -0.319766;
		cgd_hlayer_b[1] = 0.731026;
		cgd_hlayer_b[2] = 0.465485;
		cgd_hlayer_b[3] = 0.170221;
		cgd_hlayer_b[4] = -8.401651;
		cgd_hlayer_b[5] = -0.279157;
		cgd_hlayer_b[6] = 1.226954;
		cgd_hlayer_b[7] = 3.211733;
		cgd_olayer_w[0] = 0.291044;
		cgd_olayer_w[1] = -0.213008;
		cgd_olayer_w[2] = -0.229662;
		cgd_olayer_w[3] = -0.238868;
		cgd_olayer_w[4] = 1.569796;
		cgd_olayer_w[5] = -0.317901;
		cgd_olayer_w[6] = -0.547776;
		cgd_olayer_w[7] = 0.903526;
		cgd_olayer_b = 0.109786;
		cgd_c_mean = 1.039160e-12;
		cgd_c_std  = 6.428465e-13;
	end
	if (cgd_dev_sel == 2) begin // W=160 L=15 um
		cgd_hlayer_w[0] = -1.184542; 	 cgd_hlayer_w[1] = 0.155277; 	 cgd_hlayer_w[2] = -2.419363; 	 cgd_hlayer_w[3] = -3.861677; 	 cgd_hlayer_w[4] = -11.151505; 	 cgd_hlayer_w[5] = -17.378357; 	 cgd_hlayer_w[6] = 0.283196; 	 cgd_hlayer_w[7] = 1.132208;
		cgd_hlayer_b[0] = 0.260910;
		cgd_hlayer_b[1] = 0.954825;
		cgd_hlayer_b[2] = 1.183878;
		cgd_hlayer_b[3] = 1.792082;
		cgd_hlayer_b[4] = 4.992147;
		cgd_hlayer_b[5] = 7.844958;
		cgd_hlayer_b[6] = 0.459301;
		cgd_hlayer_b[7] = -0.454322;
		cgd_olayer_w[0] = 0.242025;
		cgd_olayer_w[1] = 0.116400;
		cgd_olayer_w[2] = -0.223158;
		cgd_olayer_w[3] = -0.832365;
		cgd_olayer_w[4] = 2.083997;
		cgd_olayer_w[5] = -2.574399;
		cgd_olayer_w[6] = -0.187510;
		cgd_olayer_w[7] = -0.544680;
		cgd_olayer_b = 0.044587;
		cgd_c_mean = 2.808079e-12;
		cgd_c_std  = 1.915109e-12;
	end
	if (cgd_dev_sel == 3) begin // W=160 L=20 um
		cgd_hlayer_w[0] = -17.128204; 	 cgd_hlayer_w[1] = -1.837484; 	 cgd_hlayer_w[2] = 0.840392; 	 cgd_hlayer_w[3] = -0.496152; 	 cgd_hlayer_w[4] = -12.087084; 	 cgd_hlayer_w[5] = 0.831842; 	 cgd_hlayer_w[6] = 0.007669; 	 cgd_hlayer_w[7] = 18.585323;
		cgd_hlayer_b[0] = 8.645453;
		cgd_hlayer_b[1] = 1.259560;
		cgd_hlayer_b[2] = 0.157989;
		cgd_hlayer_b[3] = -0.778064;
		cgd_hlayer_b[4] = 5.426540;
		cgd_hlayer_b[5] = -0.194759;
		cgd_hlayer_b[6] = 0.759690;
		cgd_hlayer_b[7] = -7.237505;
		cgd_olayer_w[0] = 1.442784;
		cgd_olayer_w[1] = -0.350603;
		cgd_olayer_w[2] = -0.091212;
		cgd_olayer_w[3] = -0.055844;
		cgd_olayer_w[4] = -3.959000;
		cgd_olayer_w[5] = -0.640289;
		cgd_olayer_w[6] = 0.078338;
		cgd_olayer_w[7] = -1.441658;
		cgd_olayer_b = 0.081748;
		cgd_c_mean = 3.694914e-12;
		cgd_c_std  = 2.535602e-12;
	end

	// nearest-match device selection for cgs (device parameters w, l are fixed per instance)
	cgs_best_dist = 1.0e30;
	cgs_dist = pow((w - 20.0e-6)/(160.0e-6-20.0e-6), 2) + pow((l - 20.0e-6)/(20.0e-6-15.0e-6), 2);
	if (cgs_dist < cgs_best_dist) begin cgs_best_dist = cgs_dist; cgs_dev_sel = 0; end
	cgs_dist = pow((w - 40.0e-6)/(160.0e-6-20.0e-6), 2) + pow((l - 20.0e-6)/(20.0e-6-15.0e-6), 2);
	if (cgs_dist < cgs_best_dist) begin cgs_best_dist = cgs_dist; cgs_dev_sel = 1; end
	cgs_dist = pow((w - 160.0e-6)/(160.0e-6-20.0e-6), 2) + pow((l - 15.0e-6)/(20.0e-6-15.0e-6), 2);
	if (cgs_dist < cgs_best_dist) begin cgs_best_dist = cgs_dist; cgs_dev_sel = 2; end
	cgs_dist = pow((w - 160.0e-6)/(160.0e-6-20.0e-6), 2) + pow((l - 20.0e-6)/(20.0e-6-15.0e-6), 2);
	if (cgs_dist < cgs_best_dist) begin cgs_best_dist = cgs_dist; cgs_dev_sel = 3; end
	if (cgs_dev_sel == 0) begin // W=20 L=20 um
		cgs_hlayer_w[0] = 2.279688; 	 cgs_hlayer_w[1] = -0.889313; 	 cgs_hlayer_w[2] = 1.115552; 	 cgs_hlayer_w[3] = -11.907557; 	 cgs_hlayer_w[4] = -16.879778; 	 cgs_hlayer_w[5] = -1.130590; 	 cgs_hlayer_w[6] = 2.043341; 	 cgs_hlayer_w[7] = -0.869322;
		cgs_hlayer_b[0] = -1.028029;
		cgs_hlayer_b[1] = 0.718677;
		cgs_hlayer_b[2] = 0.359450;
		cgs_hlayer_b[3] = 4.842114;
		cgs_hlayer_b[4] = 6.951757;
		cgs_hlayer_b[5] = -0.039628;
		cgs_hlayer_b[6] = -0.925680;
		cgs_hlayer_b[7] = -0.290109;
		cgs_olayer_w[0] = 0.730624;
		cgs_olayer_w[1] = 0.914272;
		cgs_olayer_w[2] = -0.129110;
		cgs_olayer_w[3] = 2.130286;
		cgs_olayer_w[4] = -2.865945;
		cgs_olayer_w[5] = 0.243519;
		cgs_olayer_w[6] = 0.293863;
		cgs_olayer_w[7] = -0.081126;
		cgs_olayer_b = -0.247864;
		cgs_c_mean = 5.009151e-13;
		cgs_c_std  = 3.371800e-13;
	end
	if (cgs_dev_sel == 1) begin // W=40 L=20 um
		cgs_hlayer_w[0] = -1.860953; 	 cgs_hlayer_w[1] = 0.705283; 	 cgs_hlayer_w[2] = -2.760894; 	 cgs_hlayer_w[3] = 17.322527; 	 cgs_hlayer_w[4] = -9.942814; 	 cgs_hlayer_w[5] = 0.107980; 	 cgs_hlayer_w[6] = 0.431006; 	 cgs_hlayer_w[7] = -0.211043;
		cgs_hlayer_b[0] = 1.695265;
		cgs_hlayer_b[1] = 0.339172;
		cgs_hlayer_b[2] = 1.312095;
		cgs_hlayer_b[3] = -7.110738;
		cgs_hlayer_b[4] = 4.029025;
		cgs_hlayer_b[5] = 0.165547;
		cgs_hlayer_b[6] = 0.072161;
		cgs_hlayer_b[7] = -1.046218;
		cgs_olayer_w[0] = 0.350378;
		cgs_olayer_w[1] = -0.069347;
		cgs_olayer_w[2] = -0.818862;
		cgs_olayer_w[3] = 2.323253;
		cgs_olayer_w[4] = 1.703456;
		cgs_olayer_w[5] = -0.036144;
		cgs_olayer_w[6] = -0.253176;
		cgs_olayer_w[7] = 0.106368;
		cgs_olayer_b = -0.111857;
		cgs_c_mean = 1.002550e-12;
		cgs_c_std  = 6.677234e-13;
	end
	if (cgs_dev_sel == 2) begin // W=160 L=15 um
		cgs_hlayer_w[0] = 17.147814; 	 cgs_hlayer_w[1] = 1.058321; 	 cgs_hlayer_w[2] = 3.774765; 	 cgs_hlayer_w[3] = -1.313953; 	 cgs_hlayer_w[4] = 4.045720; 	 cgs_hlayer_w[5] = -11.635500; 	 cgs_hlayer_w[6] = 0.181678; 	 cgs_hlayer_w[7] = -0.396709;
		cgs_hlayer_b[0] = -7.881513;
		cgs_hlayer_b[1] = 0.441258;
		cgs_hlayer_b[2] = -0.746673;
		cgs_hlayer_b[3] = 0.168713;
		cgs_hlayer_b[4] = -1.695564;
		cgs_hlayer_b[5] = 5.283528;
		cgs_hlayer_b[6] = -0.505646;
		cgs_hlayer_b[7] = -0.419578;
		cgs_olayer_w[0] = 2.925180;
		cgs_olayer_w[1] = -0.388304;
		cgs_olayer_w[2] = -0.220060;
		cgs_olayer_w[3] = -0.027328;
		cgs_olayer_w[4] = 0.877606;
		cgs_olayer_w[5] = 2.442400;
		cgs_olayer_w[6] = 0.059148;
		cgs_olayer_w[7] = 0.023442;
		cgs_olayer_b = 0.277112;
		cgs_c_mean = 2.717288e-12;
		cgs_c_std  = 1.992159e-12;
	end
	if (cgs_dev_sel == 3) begin // W=160 L=20 um
		cgs_hlayer_w[0] = 3.286913; 	 cgs_hlayer_w[1] = 20.687984; 	 cgs_hlayer_w[2] = 8.931392; 	 cgs_hlayer_w[3] = 3.539337; 	 cgs_hlayer_w[4] = 9.447197; 	 cgs_hlayer_w[5] = -1.158567; 	 cgs_hlayer_w[6] = 2.234795; 	 cgs_hlayer_w[7] = -15.561944;
		cgs_hlayer_b[0] = -0.997590;
		cgs_hlayer_b[1] = -8.104491;
		cgs_hlayer_b[2] = -2.705202;
		cgs_hlayer_b[3] = -1.086947;
		cgs_hlayer_b[4] = -4.205756;
		cgs_hlayer_b[5] = -0.423204;
		cgs_hlayer_b[6] = -0.535959;
		cgs_hlayer_b[7] = 8.254191;
		cgs_olayer_w[0] = 0.457201;
		cgs_olayer_w[1] = -1.479999;
		cgs_olayer_w[2] = -0.867922;
		cgs_olayer_w[3] = 0.981069;
		cgs_olayer_w[4] = 4.295738;
		cgs_olayer_w[5] = 0.069824;
		cgs_olayer_w[6] = -1.118264;
		cgs_olayer_w[7] = 1.359263;
		cgs_olayer_b = 0.098068;
		cgs_c_mean = 3.580102e-12;
		cgs_c_std  = 2.626697e-12;
	end

	end // end of initialization

	// ==== ID: preprocessing (min-max to [0,1], clamped to training range) ====
	vg_s = (V(G,S) - vg_lo) / (vg_hi - vg_lo);
	if (vg_s < 0) vg_s = 0;
	if (vg_s > 1) vg_s = 1;

	vd_s = (V(D,S) - vd_lo) / (vd_hi - vd_lo);
	if (vd_s < 0) vd_s = 0;
	if (vd_s > 1) vd_s = 1;

	width_s = (w - w_lo) / (w_hi - w_lo);
	if (width_s < 0) width_s = 0;
	if (width_s > 1) width_s = 1;

	length_s = (l - l_lo) / (l_hi - l_lo);
	if (length_s < 0) length_s = 0;
	if (length_s > 1) length_s = 1;

	temp  = 0;
	temp1 = 0;
	for (i = 0; i < NNHL; i = i + 1) begin
		hlayer_v[i] = vg_s*hlayer_w[NI*i]   + vd_s*hlayer_w[NI*i+1]
		            + width_s*hlayer_w[NI*i+2] + length_s*hlayer_w[NI*i+3]
		            + hlayer_b[i];
		hlayer_y[i] = tanh(hlayer_v[i]);
		temp  = temp  + olayer_w[i]*hlayer_w[NI*i]   * (1 - hlayer_y[i]*hlayer_y[i]);
		temp1 = temp1 + olayer_w[i]*hlayer_w[NI*i+1] * (1 - hlayer_y[i]*hlayer_y[i]);
	end

	olayer_v = 0;
	for (jj = 0; jj < NNHL; jj = jj + 1) begin
		olayer_v = olayer_v + hlayer_y[jj]*olayer_w[jj];
	end
	olayer_v = olayer_v + olayer_b;

	log_id = olayer_v*y_std + y_mean;
	id = pow(10.0, log_id);

	gm  = id * `M_LN10 * y_std * temp  / (vg_hi - vg_lo);
	gds = id * `M_LN10 * y_std * temp1 / (vd_hi - vd_lo);

	I(D,S) <+ id;

	// ==== CGD: MLP forward pass on VG -> capacitance [F] (device-selected weights) ====
	vgc_s = (V(G,S) - cap_vg_lo) / (cap_vg_hi - cap_vg_lo);
	if (vgc_s < 0) vgc_s = 0;
	if (vgc_s > 1) vgc_s = 1;
	cgd_out = 0;
	for (i = 0; i < CAP_NNHL; i = i + 1) begin
		cgd_hlayer_y[i] = tanh(vgc_s*cgd_hlayer_w[i] + cgd_hlayer_b[i]);
		cgd_out = cgd_out + cgd_hlayer_y[i]*cgd_olayer_w[i];
	end
	cgd_out = cgd_out + cgd_olayer_b;
	cgd = cgd_out*cgd_c_std + cgd_c_mean;
	if (cgd < 0) cgd = 0;   // capacitance floor: reject small extrapolation excursions below 0

	// ==== CGS: MLP forward pass on VG -> capacitance [F] (device-selected weights) ====
	cgs_out = 0;
	for (i = 0; i < CAP_NNHL; i = i + 1) begin
		cgs_hlayer_y[i] = tanh(vgc_s*cgs_hlayer_w[i] + cgs_hlayer_b[i]);
		cgs_out = cgs_out + cgs_hlayer_y[i]*cgs_olayer_w[i];
	end
	cgs_out = cgs_out + cgs_olayer_b;
	cgs = cgs_out*cgs_c_std + cgs_c_mean;
	if (cgs < 0) cgs = 0;   // capacitance floor: reject small extrapolation excursions below 0

	// Charge-based capacitive branch currents (well-posed for the simulator's
	// charge-conservation checks, unlike a raw I <+ C*ddt(V) linear-cap form)
	qgd = cgd * V(G,D);
	qgs = cgs * V(G,S);
	I(G,D) <+ ddt(qgd);
	I(G,S) <+ ddt(qgs);

	end

endmodule
