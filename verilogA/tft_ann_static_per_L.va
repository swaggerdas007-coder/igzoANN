// VerilogA for a-GIZO TFT ANN static model -- PER-LENGTH ENSEMBLE VARIANT.
//
// Instead of one 4-input (VG,VD,W,L) network, this merges 4 separate
// 3-input (VG,VD,W) networks, one trained per measured channel length
// (L = 5, 10, 15, 20 um). Each subnetwork only ever had to fit its
// own W range using its own geometry's data -- no cross-L interpolation,
// no L-imbalance in the training loss. `l` is a device parameter fixed at
// elaboration time, so the nearest trained L's weight table is selected
// once in `initial_step` (nearest-match boundaries at 7.5, 12.5, 17.5 um) --
// zero runtime cost versus the unified 4-input model.
//
// Architecture per subnetwork follows Eq. (1)-(2) of Bahubalindruni et al.,
// "a-GIZO TFT neural modeling, circuit simulation and validation",
// Solid-State Electronics 105 (2015) 30-36:
//     yh = tanh(x . wh + bh)      hidden layer
//     y  = yh . wo + bo           output layer (LINEAR, no activation)
//
// Auto-generated by scripts/export_verilog_a_per_L.py from
// trained_ANN/per_L/weights_L*.json. Do not hand-edit the weight/bias
// tables -- regenerate instead.

`include "constants.h"
`include "disciplines.h"

module tft_ann_static_per_L(D, G, S);
inout G, D, S;
electrical D, G, S;

parameter integer NI = 3;      // no. of inputs: VG, VD, W (L selects the subnetwork)
parameter integer NNHL = 22;    // no. of neurons in hidden layer (shared by all 4 subnetworks)
parameter integer NO = 1;

// device geometry (SI units, matching Spectre convention)
parameter real w = 40e-6 from [5e-6:160e-6];  // channel width, training range [5,160] um
parameter real l = 10e-6 from [3e-6:22e-6];  // channel length -- nearest of {5, 10, 15, 20} um is used

// hidden layer
real hlayer_w[0:(NI*NNHL)-1];
real hlayer_b[0:NNHL-1];
real hlayer_y[0:NNHL-1];
real hlayer_v[0:NNHL-1];

// output layer (linear)
real olayer_w[0:(NO*NNHL)-1];
real olayer_b[0:NO-1];
real olayer_v[0:NO-1];

real vg_s, vd_s, width_s;   // inputs scaled to [0,1]
real log_id, id;
real gm, gds, temp, temp1;
integer i, ii, jj;
integer l_bucket;
real l_um;

// input scaling (min-max, [0,1]) -- shared across subnetworks, must match
// trained_ANN/ann_train_per_L.py's FEATURE_BOUNDS exactly
real vg_lo, vg_hi, vd_lo, vd_hi, w_lo, w_hi;

// output de-standardization: log10(|ID|) = raw_output*y_std + y_mean
// (each subnetwork has its own y_mean/y_std -- set alongside its weights below)
real y_mean, y_std;

analog begin
	@(initial_step or initial_step("static")) begin

	vg_lo = -5.000000; vg_hi = 5.000000;
	vd_lo = 0.000000; vd_hi = 5.000000;
	w_lo  = 5.0e-6; w_hi  = 160.0e-6;

	// select nearest trained L (device parameter, fixed per instance)
	l_um = l * 1e6;
	if (l_um < 7.5) l_bucket = 0;
	else if (l_um < 12.5) l_bucket = 1;
	else if (l_um < 17.5) l_bucket = 2;
	else l_bucket = 3;

	if (l_bucket == 0) begin // L = 5 um
		hlayer_w[0] = 1.431034; 	 hlayer_w[1] = -0.001955; 	 hlayer_w[2] = 1.989707;
		hlayer_w[3] = 7.976792; 	 hlayer_w[4] = -0.016331; 	 hlayer_w[5] = 0.020773;
		hlayer_w[6] = 0.013221; 	 hlayer_w[7] = 0.182321; 	 hlayer_w[8] = 2.541861;
		hlayer_w[9] = -1.011383; 	 hlayer_w[10] = 7.088341; 	 hlayer_w[11] = 0.086173;
		hlayer_w[12] = 1.924153; 	 hlayer_w[13] = -0.483373; 	 hlayer_w[14] = -0.215896;
		hlayer_w[15] = 0.333364; 	 hlayer_w[16] = 3.560044; 	 hlayer_w[17] = 0.200577;
		hlayer_w[18] = -1.357179; 	 hlayer_w[19] = -0.229485; 	 hlayer_w[20] = -0.534977;
		hlayer_w[21] = 0.916793; 	 hlayer_w[22] = -17.460695; 	 hlayer_w[23] = -0.001541;
		hlayer_w[24] = -11.657341; 	 hlayer_w[25] = 0.010293; 	 hlayer_w[26] = -0.143016;
		hlayer_w[27] = -0.007775; 	 hlayer_w[28] = -0.006793; 	 hlayer_w[29] = -0.000449;
		hlayer_w[30] = 3.028552; 	 hlayer_w[31] = -0.015778; 	 hlayer_w[32] = 0.196041;
		hlayer_w[33] = -0.141035; 	 hlayer_w[34] = 0.122128; 	 hlayer_w[35] = 0.099336;
		hlayer_w[36] = -0.001631; 	 hlayer_w[37] = -0.005539; 	 hlayer_w[38] = -0.026158;
		hlayer_w[39] = -0.706720; 	 hlayer_w[40] = 0.022716; 	 hlayer_w[41] = -0.024471;
		hlayer_w[42] = 0.881651; 	 hlayer_w[43] = 0.059294; 	 hlayer_w[44] = 0.006891;
		hlayer_w[45] = -0.321747; 	 hlayer_w[46] = 2.161429; 	 hlayer_w[47] = 0.298103;
		hlayer_w[48] = 2.286460; 	 hlayer_w[49] = -6.649845; 	 hlayer_w[50] = -0.033921;
		hlayer_w[51] = -0.347884; 	 hlayer_w[52] = -0.635132; 	 hlayer_w[53] = 1.064954;
		hlayer_w[54] = 0.843160; 	 hlayer_w[55] = 0.251655; 	 hlayer_w[56] = -0.200325;
		hlayer_w[57] = -0.068079; 	 hlayer_w[58] = 0.654386; 	 hlayer_w[59] = -0.736981;
		hlayer_w[60] = -0.245764; 	 hlayer_w[61] = 0.127581; 	 hlayer_w[62] = 0.068843;
		hlayer_w[63] = 0.021315; 	 hlayer_w[64] = -0.000301; 	 hlayer_w[65] = -0.001660;
		hlayer_b[0] = 0.015199;
		hlayer_b[1] = -3.041688;
		hlayer_b[2] = 0.038343;
		hlayer_b[3] = 0.455778;
		hlayer_b[4] = 0.110954;
		hlayer_b[5] = 0.087295;
		hlayer_b[6] = 1.058195;
		hlayer_b[7] = -1.170406;
		hlayer_b[8] = 4.044889;
		hlayer_b[9] = -0.002628;
		hlayer_b[10] = -1.002076;
		hlayer_b[11] = 0.615537;
		hlayer_b[12] = 0.018728;
		hlayer_b[13] = 0.886548;
		hlayer_b[14] = -0.981602;
		hlayer_b[15] = 0.280307;
		hlayer_b[16] = -1.088942;
		hlayer_b[17] = -0.077296;
		hlayer_b[18] = 0.899390;
		hlayer_b[19] = -0.146271;
		hlayer_b[20] = 0.751090;
		hlayer_b[21] = -0.007786;
		olayer_w[0] = -0.504020;
		olayer_w[1] = 3.573224;
		olayer_w[2] = 0.414373;
		olayer_w[3] = -0.467319;
		olayer_w[4] = 0.091784;
		olayer_w[5] = 0.342009;
		olayer_w[6] = -0.701454;
		olayer_w[7] = -1.559918;
		olayer_w[8] = 2.288058;
		olayer_w[9] = -0.001628;
		olayer_w[10] = -0.761115;
		olayer_w[11] = -0.222576;
		olayer_w[12] = 0.003201;
		olayer_w[13] = -0.275272;
		olayer_w[14] = 0.299860;
		olayer_w[15] = -0.275364;
		olayer_w[16] = -0.349940;
		olayer_w[17] = -0.232262;
		olayer_w[18] = -0.503631;
		olayer_w[19] = -0.199746;
		olayer_w[20] = -0.241064;
		olayer_w[21] = 0.001051;
		olayer_b[0] = -0.298908;
		y_mean = -8.304921;
		y_std  = 3.266108;
	end
	if (l_bucket == 1) begin // L = 10 um
		hlayer_w[0] = -0.999451; 	 hlayer_w[1] = 0.141661; 	 hlayer_w[2] = 2.114585;
		hlayer_w[3] = 6.032990; 	 hlayer_w[4] = -0.074772; 	 hlayer_w[5] = 0.013944;
		hlayer_w[6] = -2.926126; 	 hlayer_w[7] = 0.186270; 	 hlayer_w[8] = 1.981456;
		hlayer_w[9] = -0.640939; 	 hlayer_w[10] = 6.737935; 	 hlayer_w[11] = 0.051419;
		hlayer_w[12] = 0.693411; 	 hlayer_w[13] = -0.317366; 	 hlayer_w[14] = -0.313852;
		hlayer_w[15] = -0.773085; 	 hlayer_w[16] = 7.891945; 	 hlayer_w[17] = 0.045702;
		hlayer_w[18] = -1.421703; 	 hlayer_w[19] = -0.003293; 	 hlayer_w[20] = -0.639378;
		hlayer_w[21] = -0.220319; 	 hlayer_w[22] = -2.921270; 	 hlayer_w[23] = -0.051391;
		hlayer_w[24] = -8.437459; 	 hlayer_w[25] = 0.047897; 	 hlayer_w[26] = -0.102206;
		hlayer_w[27] = -0.558943; 	 hlayer_w[28] = 0.337884; 	 hlayer_w[29] = -0.396518;
		hlayer_w[30] = 2.532748; 	 hlayer_w[31] = -0.403935; 	 hlayer_w[32] = -0.153180;
		hlayer_w[33] = -0.277695; 	 hlayer_w[34] = -0.111376; 	 hlayer_w[35] = -0.224816;
		hlayer_w[36] = -0.530782; 	 hlayer_w[37] = 0.189668; 	 hlayer_w[38] = -0.336922;
		hlayer_w[39] = -2.930912; 	 hlayer_w[40] = 0.146511; 	 hlayer_w[41] = -1.428291;
		hlayer_w[42] = 0.688747; 	 hlayer_w[43] = 0.262538; 	 hlayer_w[44] = 0.366529;
		hlayer_w[45] = -0.974654; 	 hlayer_w[46] = 1.153697; 	 hlayer_w[47] = -0.004520;
		hlayer_w[48] = 1.659156; 	 hlayer_w[49] = -0.600881; 	 hlayer_w[50] = -0.560320;
		hlayer_w[51] = -1.075488; 	 hlayer_w[52] = -0.042937; 	 hlayer_w[53] = 1.050893;
		hlayer_w[54] = -0.319883; 	 hlayer_w[55] = 0.018007; 	 hlayer_w[56] = -0.225157;
		hlayer_w[57] = -0.129659; 	 hlayer_w[58] = 0.045791; 	 hlayer_w[59] = -0.335223;
		hlayer_w[60] = -0.322315; 	 hlayer_w[61] = -0.211542; 	 hlayer_w[62] = -0.289940;
		hlayer_w[63] = -0.421576; 	 hlayer_w[64] = 0.351105; 	 hlayer_w[65] = 0.147322;
		hlayer_b[0] = -0.503374;
		hlayer_b[1] = -2.612509;
		hlayer_b[2] = -0.315612;
		hlayer_b[3] = 0.025715;
		hlayer_b[4] = 0.014989;
		hlayer_b[5] = 0.855832;
		hlayer_b[6] = 1.439507;
		hlayer_b[7] = -0.215885;
		hlayer_b[8] = 3.141289;
		hlayer_b[9] = 0.330010;
		hlayer_b[10] = -1.401616;
		hlayer_b[11] = 0.501005;
		hlayer_b[12] = 0.516277;
		hlayer_b[13] = 1.626597;
		hlayer_b[14] = -1.096957;
		hlayer_b[15] = 0.108065;
		hlayer_b[16] = -1.080271;
		hlayer_b[17] = -0.105961;
		hlayer_b[18] = 0.580453;
		hlayer_b[19] = 0.231713;
		hlayer_b[20] = 0.618833;
		hlayer_b[21] = -0.026269;
		olayer_w[0] = -0.638987;
		olayer_w[1] = 3.184335;
		olayer_w[2] = 0.702924;
		olayer_w[3] = -0.408859;
		olayer_w[4] = 0.032637;
		olayer_w[5] = 1.374250;
		olayer_w[6] = -1.118060;
		olayer_w[7] = -0.315946;
		olayer_w[8] = 1.676528;
		olayer_w[9] = -0.222722;
		olayer_w[10] = -0.907069;
		olayer_w[11] = -0.260657;
		olayer_w[12] = -0.307663;
		olayer_w[13] = 0.692223;
		olayer_w[14] = 0.607378;
		olayer_w[15] = -0.403154;
		olayer_w[16] = -0.306552;
		olayer_w[17] = -0.372556;
		olayer_w[18] = -0.384292;
		olayer_w[19] = -0.087629;
		olayer_w[20] = -0.353463;
		olayer_w[21] = -0.001363;
		olayer_b[0] = -0.190801;
		y_mean = -8.596218;
		y_std  = 3.156226;
	end
	if (l_bucket == 2) begin // L = 15 um
		hlayer_w[0] = -0.588084; 	 hlayer_w[1] = -0.008116; 	 hlayer_w[2] = -0.243091;
		hlayer_w[3] = 5.986193; 	 hlayer_w[4] = -0.087929; 	 hlayer_w[5] = 0.287883;
		hlayer_w[6] = -2.005652; 	 hlayer_w[7] = 0.058239; 	 hlayer_w[8] = 1.272178;
		hlayer_w[9] = -0.762925; 	 hlayer_w[10] = 4.035315; 	 hlayer_w[11] = 0.142988;
		hlayer_w[12] = 0.577456; 	 hlayer_w[13] = -0.192232; 	 hlayer_w[14] = -0.319352;
		hlayer_w[15] = -0.979960; 	 hlayer_w[16] = 9.811749; 	 hlayer_w[17] = 0.002410;
		hlayer_w[18] = -1.290223; 	 hlayer_w[19] = 0.015506; 	 hlayer_w[20] = -0.886589;
		hlayer_w[21] = -0.269169; 	 hlayer_w[22] = -1.578219; 	 hlayer_w[23] = 0.036895;
		hlayer_w[24] = -8.257616; 	 hlayer_w[25] = 0.038663; 	 hlayer_w[26] = -0.523715;
		hlayer_w[27] = -0.001565; 	 hlayer_w[28] = -0.000061; 	 hlayer_w[29] = 0.005626;
		hlayer_w[30] = 2.975429; 	 hlayer_w[31] = -0.276694; 	 hlayer_w[32] = 0.141745;
		hlayer_w[33] = -0.554889; 	 hlayer_w[34] = -0.184101; 	 hlayer_w[35] = 0.226198;
		hlayer_w[36] = -1.063641; 	 hlayer_w[37] = 0.069683; 	 hlayer_w[38] = -0.641080;
		hlayer_w[39] = -2.364180; 	 hlayer_w[40] = 0.017967; 	 hlayer_w[41] = -1.483700;
		hlayer_w[42] = 0.926116; 	 hlayer_w[43] = 0.179219; 	 hlayer_w[44] = -0.141749;
		hlayer_w[45] = -0.798123; 	 hlayer_w[46] = 0.957280; 	 hlayer_w[47] = 0.064076;
		hlayer_w[48] = 0.763654; 	 hlayer_w[49] = -1.776028; 	 hlayer_w[50] = -0.278291;
		hlayer_w[51] = -0.402152; 	 hlayer_w[52] = -0.345503; 	 hlayer_w[53] = 0.254613;
		hlayer_w[54] = -0.625278; 	 hlayer_w[55] = -0.038012; 	 hlayer_w[56] = 0.153997;
		hlayer_w[57] = -0.009520; 	 hlayer_w[58] = 0.004214; 	 hlayer_w[59] = 0.016544;
		hlayer_w[60] = -0.567937; 	 hlayer_w[61] = -0.256562; 	 hlayer_w[62] = 0.137528;
		hlayer_w[63] = -0.469908; 	 hlayer_w[64] = 0.269026; 	 hlayer_w[65] = 0.235726;
		hlayer_b[0] = 0.502944;
		hlayer_b[1] = -2.852150;
		hlayer_b[2] = -0.446344;
		hlayer_b[3] = 0.537943;
		hlayer_b[4] = -0.019210;
		hlayer_b[5] = 1.123710;
		hlayer_b[6] = 1.379640;
		hlayer_b[7] = -0.298553;
		hlayer_b[8] = 3.495040;
		hlayer_b[9] = -0.001536;
		hlayer_b[10] = -1.685965;
		hlayer_b[11] = 0.411882;
		hlayer_b[12] = 0.222702;
		hlayer_b[13] = 1.267893;
		hlayer_b[14] = -0.895921;
		hlayer_b[15] = -0.095037;
		hlayer_b[16] = -0.654059;
		hlayer_b[17] = 0.151174;
		hlayer_b[18] = 0.462377;
		hlayer_b[19] = -0.003675;
		hlayer_b[20] = 0.486736;
		hlayer_b[21] = -0.050928;
		olayer_w[0] = -0.232314;
		olayer_w[1] = 3.662105;
		olayer_w[2] = 0.527377;
		olayer_w[3] = -0.233219;
		olayer_w[4] = 0.203784;
		olayer_w[5] = 0.989733;
		olayer_w[6] = -0.975912;
		olayer_w[7] = -0.188530;
		olayer_w[8] = 1.862503;
		olayer_w[9] = -0.000553;
		olayer_w[10] = -1.399597;
		olayer_w[11] = -0.364964;
		olayer_w[12] = 0.140999;
		olayer_w[13] = 0.556191;
		olayer_w[14] = 0.436070;
		olayer_w[15] = -0.430079;
		olayer_w[16] = -0.092028;
		olayer_w[17] = -0.194714;
		olayer_w[18] = -0.443431;
		olayer_w[19] = -0.001842;
		olayer_w[20] = -0.356402;
		olayer_w[21] = -0.094349;
		olayer_b[0] = 0.068050;
		y_mean = -8.673825;
		y_std  = 3.152320;
	end
	if (l_bucket == 3) begin // L = 20 um
		hlayer_w[0] = 1.918003; 	 hlayer_w[1] = -0.082733; 	 hlayer_w[2] = -0.070199;
		hlayer_w[3] = 6.555911; 	 hlayer_w[4] = -0.076838; 	 hlayer_w[5] = -0.054923;
		hlayer_w[6] = -1.114603; 	 hlayer_w[7] = 0.023831; 	 hlayer_w[8] = 1.452928;
		hlayer_w[9] = -1.582798; 	 hlayer_w[10] = 1.574107; 	 hlayer_w[11] = 0.100762;
		hlayer_w[12] = 0.300973; 	 hlayer_w[13] = -0.084757; 	 hlayer_w[14] = -0.317347;
		hlayer_w[15] = -0.974437; 	 hlayer_w[16] = 20.127594; 	 hlayer_w[17] = 0.081612;
		hlayer_w[18] = -1.269221; 	 hlayer_w[19] = -0.094641; 	 hlayer_w[20] = -0.444437;
		hlayer_w[21] = 0.001370; 	 hlayer_w[22] = 0.002707; 	 hlayer_w[23] = 0.018986;
		hlayer_w[24] = -8.282324; 	 hlayer_w[25] = 0.021691; 	 hlayer_w[26] = -0.028191;
		hlayer_w[27] = 0.000828; 	 hlayer_w[28] = 0.001598; 	 hlayer_w[29] = 0.011753;
		hlayer_w[30] = 2.630985; 	 hlayer_w[31] = -0.198704; 	 hlayer_w[32] = -0.169762;
		hlayer_w[33] = -0.318407; 	 hlayer_w[34] = -0.142933; 	 hlayer_w[35] = -0.047985;
		hlayer_w[36] = -0.000967; 	 hlayer_w[37] = -0.001826; 	 hlayer_w[38] = -0.013423;
		hlayer_w[39] = -0.790438; 	 hlayer_w[40] = 0.227630; 	 hlayer_w[41] = -0.239064;
		hlayer_w[42] = 0.905884; 	 hlayer_w[43] = 0.032068; 	 hlayer_w[44] = 0.095406;
		hlayer_w[45] = -0.720799; 	 hlayer_w[46] = 0.701784; 	 hlayer_w[47] = 0.073395;
		hlayer_w[48] = 2.323874; 	 hlayer_w[49] = -0.841856; 	 hlayer_w[50] = -0.139597;
		hlayer_w[51] = -0.337685; 	 hlayer_w[52] = -1.277076; 	 hlayer_w[53] = -0.004474;
		hlayer_w[54] = -0.516149; 	 hlayer_w[55] = 0.005521; 	 hlayer_w[56] = -0.030381;
		hlayer_w[57] = -0.180288; 	 hlayer_w[58] = 0.232755; 	 hlayer_w[59] = -0.251395;
		hlayer_w[60] = -0.388358; 	 hlayer_w[61] = -0.191085; 	 hlayer_w[62] = -0.148578;
		hlayer_w[63] = -0.206694; 	 hlayer_w[64] = 0.207658; 	 hlayer_w[65] = 0.075342;
		hlayer_b[0] = 0.454775;
		hlayer_b[1] = -2.958452;
		hlayer_b[2] = -0.179438;
		hlayer_b[3] = 0.356567;
		hlayer_b[4] = 0.022536;
		hlayer_b[5] = 1.035589;
		hlayer_b[6] = 1.385067;
		hlayer_b[7] = -0.010953;
		hlayer_b[8] = 3.274680;
		hlayer_b[9] = -0.006668;
		hlayer_b[10] = -1.213141;
		hlayer_b[11] = 0.297405;
		hlayer_b[12] = 0.007606;
		hlayer_b[13] = 0.776409;
		hlayer_b[14] = -1.018123;
		hlayer_b[15] = -0.132143;
		hlayer_b[16] = -1.234397;
		hlayer_b[17] = -0.022070;
		hlayer_b[18] = 0.554164;
		hlayer_b[19] = 0.110339;
		hlayer_b[20] = 0.443887;
		hlayer_b[21] = -0.023680;
		olayer_w[0] = -0.390319;
		olayer_w[1] = 3.136108;
		olayer_w[2] = -0.353755;
		olayer_w[3] = -0.291869;
		olayer_w[4] = -0.003408;
		olayer_w[5] = 0.919593;
		olayer_w[6] = -1.055144;
		olayer_w[7] = -0.000455;
		olayer_w[8] = 1.664241;
		olayer_w[9] = -0.000532;
		olayer_w[10] = -1.168016;
		olayer_w[11] = -0.008416;
		olayer_w[12] = 0.000578;
		olayer_w[13] = -0.328372;
		olayer_w[14] = 0.443985;
		olayer_w[15] = -0.219254;
		olayer_w[16] = -0.590897;
		olayer_w[17] = -0.219640;
		olayer_w[18] = -0.224506;
		olayer_w[19] = -0.010195;
		olayer_w[20] = -0.051167;
		olayer_w[21] = -0.004736;
		olayer_b[0] = -0.035663;
		y_mean = -8.637272;
		y_std  = 3.115042;
	end

	end // end of initialization

	// preprocessing: scale inputs to [0,1] using training bounds, clamped
	// to the training range to avoid extrapolation blow-up outside it
	vg_s = (V(G,S) - vg_lo) / (vg_hi - vg_lo);
	if (vg_s < 0) vg_s = 0;
	if (vg_s > 1) vg_s = 1;

	vd_s = (V(D,S) - vd_lo) / (vd_hi - vd_lo);
	if (vd_s < 0) vd_s = 0;
	if (vd_s > 1) vd_s = 1;

	width_s = (w - w_lo) / (w_hi - w_lo);
	if (width_s < 0) width_s = 0;
	if (width_s > 1) width_s = 1;

	temp  = 0;   // accumulates d(raw_output)/d(vg_s) for gm
	temp1 = 0;   // accumulates d(raw_output)/d(vd_s) for gds

	for (i = 0; i < NNHL; i = i + 1) begin
		hlayer_v[i] = vg_s*hlayer_w[NI*i] + vd_s*hlayer_w[NI*i+1] + width_s*hlayer_w[NI*i+2]
		            + hlayer_b[i];
		hlayer_y[i] = tanh(hlayer_v[i]);
		temp  = temp  + olayer_w[i]*hlayer_w[NI*i]   * (1 - hlayer_y[i]*hlayer_y[i]);
		temp1 = temp1 + olayer_w[i]*hlayer_w[NI*i+1] * (1 - hlayer_y[i]*hlayer_y[i]);
	end

	for (ii = 0; ii < NO; ii = ii + 1) begin
		olayer_v[ii] = 0;
		for (jj = 0; jj < NNHL; jj = jj + 1) begin
			olayer_v[ii] = olayer_v[ii] + hlayer_y[jj]*olayer_w[jj];
		end
		olayer_v[ii] = olayer_v[ii] + olayer_b[ii];   // linear output, no tanh
	end

	// post-processing: undo target standardization and the log10 transform
	log_id = olayer_v[0]*y_std + y_mean;
	id = pow(10.0, log_id);

	// small-signal parameters
	gm  = id * `M_LN10 * y_std * temp  / (vg_hi - vg_lo);
	gds = id * `M_LN10 * y_std * temp1 / (vd_hi - vd_lo);

	I(D,S) <+ id;
	I(G,S) <+ 0;
	I(G,D) <+ 0;

	end

endmodule
