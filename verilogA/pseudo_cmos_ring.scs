// Spectre netlist: a-IGZO pseudo-CMOS bootstrapped NOT gate and ring oscillator.
//
// Companion to outputs/pseudo_cmos/. The sizing is the one chosen in
// scripts/pseudo_cmos_best.py; the Python engine in src/logic_sim.py and this
// netlist describe the same circuit, so this is how to reproduce the study in a
// real simulator.
//
//   spectre pseudo_cmos_ring.scs +escchars +log ./spectre.out
//
// NOT RUN BY ANYTHING IN THIS REPO AND NOT EXECUTED HERE -- no Spectre license
// in this environment. Treat it as a starting point whose topology, sizing and
// expected numbers are verified (by src/logic_sim.py), but whose syntax is not.
//
// Read outputs/pseudo_cmos/README.md section 2 first. Two things will bite:
//
//  1. ntft_full.va writes I(G,D) <+ ddt(cgd*V(G,D)), so the effective dQ/dV is
//     C + V*dC/dV, which goes NEGATIVE (to -17 pF where C is +6 pF) across the
//     turn-on knee every logic node crosses. Transient will very likely stall
//     above ~1.3 V until the .va is given a charge-based Q = integral(C dV).
//  2. The model clamps V(D,S) at 0, so it cannot conduct in reverse. M1 relies
//     on blocking when node X is bootstrapped above VDD -- it does block, but
//     for the wrong reason (an input clamp, not the physics), and any device
//     that genuinely reverses will be wrong. src/logic_sim.py symmetrises the
//     terminals to fix this; a Verilog-A fix would do the same inside the .va.

simulator lang=spectre
ahdl_include "ntft_full.va"

// ---- the gate: 5/20/160/40 um, L = 5 um, Cboot = 1 pF -------------------
// M1  weak saturated load, gate on VDD, charges node X and blocks when X > VDD
// M2  first-stage driver: X is the inverse of IN
// M3  output pull-up, gate on X (a source follower -- hence the bootstrap)
// M4  output pull-down
// Cb  bootstrap: couples the rising output back into M3's own gate
subckt pcmos_inv (in out vdd vss)
  parameters w1=5e-6 w2=20e-6 w3=160e-6 w4=40e-6 lch=5e-6 cb=1e-12
  M1 (vdd vdd  x  ) tft_ann_full_model w=w1 l=lch
  M2 (x   in   vss) tft_ann_full_model w=w2 l=lch
  M3 (vdd x    out) tft_ann_full_model w=w3 l=lch
  M4 (out in   vss) tft_ann_full_model w=w4 l=lch
  Cb (out x) capacitor c=cb
ends pcmos_inv

// ---- 5-stage ring --------------------------------------------------------
parameters VDD=3.0
V0 (vdd 0) vsource dc=VDD type=dc

X0 (n4 n0 vdd 0) pcmos_inv
X1 (n0 n1 vdd 0) pcmos_inv
X2 (n1 n2 vdd 0) pcmos_inv
X3 (n2 n3 vdd 0) pcmos_inv
X4 (n3 n4 vdd 0) pcmos_inv

// Start it. The symmetric DC point is unstable but a solver will happily sit on
// it, so the ring is kicked with alternating rails.
//
// maxstep matters more than it looks: the period is ~5 us at VDD = 3 V and a
// step limit loose compared with THAT (not with the stop time) lets the
// integrator damp a marginal oscillation into silence. Getting this wrong here
// faked a 0.9 V supply floor until the step cap was tied to the period --
// 25 ns is ~200 steps per period.
ic n0=VDD n1=0 n2=VDD n3=0 n4=VDD

tran tran stop=60u ic=all errpreset=conservative maxstep=25n

// Supply sweep. Measured window (see the README): oscillation from ~0.8 V,
// swing >= 90% of VDD over roughly 2.0-3.5 V, f ~ VDD^1.00.
sweepvdd sweep param=VDD values=[1.0 1.5 2.0 2.5 3.0 3.5 4.0] {
  tr tran stop=60u ic=all errpreset=conservative maxstep=25n
}

// ---- single gate, DC transfer curve -------------------------------------
// Vx is swept 0 -> VDD; expect VOH ~ 2.90 V, VOL ~ 0.086 V, |dVout/dVin| ~ 2.6
// peak and ~2.05 at the trip point VM = 1.03 V, at VDD = 3 V.
Vin (vin 0) vsource dc=0
XD  (vin vo vdd 0) pcmos_inv
dcvtc dc param=dc dev=Vin start=0 stop=3.0 step=0.01
