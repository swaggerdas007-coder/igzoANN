// IGZO TFT compact DC model -- CAMCAS, Appendix F of C. de Almeida,
// "Development of IGZO thin-film transistors (TFTs) compact models" (2025),
// re-parameterized on this repository's measurements.
//
// Structure and equations follow Listing F.1 line for line. Every model
// parameter is a function of the instance geometry (W, L in um):
//   Von, alpha, kappa, G0, Ioff (lin & sat):
//       X(L,W) = (aW*W + a0)*L^2 + (bW*W + b0)*L + (cW*W + c0)   (Eqs. 3.5-3.16)
//   DeltaL(W), RSD(W): straight lines in W                      (Eqs. 3.17-3.18)
//   m: one global constant.
// Coefficients: parameters extracted per device with the thesis's
// automatic procedure (Sec. 3.2), scaled with the thesis two-step fit
// (quadratic in L per width, then linear in W),
// then Von/alpha/kappa/G0 coefficients refined against the fit devices'
// measured currents (scripts/camcas_thesis/refine.py).
// Fit geometries (W/L um): 20/5, 20/10, 20/15, 20/20, 40/5, 40/10, 40/15, 40/20, 80/5, 80/10, 80/15, 80/20, 160/5, 160/10, 160/15, 160/20.
// Held out, never used for fitting: 5/5, 10/5, 10/10. Coefficient variant:
// "sequential_g". Valid range: W = 20..160 um, L = 5..20 um, 0 <= VDS.
//
// Differences from Listing F.1 (both on the RSD line, see
// scripts/camcas_thesis/step4_export_va.py): RSD_func is in kOhm and is
// converted with *1e3 (F.1 divides by 100), and it is clamped at 0.
// The charge block is copied verbatim from F.1 and was not re-extracted.
//
// Auto-generated by scripts/camcas_thesis/step4_export_va.py -- regenerate,
// don't hand-edit.

`include "constants.vams"
`include "disciplines.vams"

module tft_camcas_thesis(d, g, s);

inout d, g, s;
electrical d, g, s;

parameter real W = 40; // um
parameter real L = 10; // um

parameter real VH = 5;
parameter real VDSref_lin = 0.1;
parameter real VDSref_sat = 5;

parameter real eps_ox = 3.45e-11;
parameter real tox = 0.1e-6;

parameter real m = 1.85594;

real Vgs, Vds, Vgd, Von_lin, Von_sat, Von_eff;
real alpha_lin, alpha_sat;
real G0_lin, G0_sat;
real Ioff_lin, Ioff_sat;
real DeltaL, RSD;
real k_lin, k_sat;
real Lp;
real Ids_sat, Ids_lin;
real Ids_total;
real term_exp;
real G;
real Covs, Covd, CCH;
real Qovs, Qovd, Qch;
real Lov, Lovch;

analog function real von_lin_func;
	input Lm, Wm;
	real Lm, Wm;
	real L2;
	begin
		L2 = Lm*Lm;
		von_lin_func = ((-5.2636393047e-06 * Wm + 7.1456203737e-04) * L2) +
		         ((3.8878212246e-04 * Wm + -2.2613333644e-02) * Lm) +
		         (-3.5702995299e-03 * Wm + -3.5120444646e-01);
	end
endfunction

analog function real von_sat_func;
	input Lm, Wm;
	real Lm, Wm;
	real L2;
	begin
		L2 = Lm*Lm;
		von_sat_func = ((-3.1680991701e-05 * Wm + 1.2676120244e-03) * L2) +
		         ((7.5952494258e-04 * Wm + -1.2485429777e-02) * Lm) +
		         (-4.3330867467e-03 * Wm + -4.6179295283e-01);
	end
endfunction

analog function real alpha_lin_func;
	input Lm, Wm;
	real Lm, Wm;
	real L2;
	begin
		L2 = Lm*Lm;
		alpha_lin_func = ((-2.7191980747e-05 * Wm + 2.1892526575e-03) * L2) +
		         ((6.2624096439e-04 * Wm + -4.3691592329e-02) * Lm) +
		         (-3.2633471307e-03 * Wm + -2.4873351550e-01);
	end
endfunction

analog function real alpha_sat_func;
	input Lm, Wm;
	real Lm, Wm;
	real L2;
	begin
		L2 = Lm*Lm;
		alpha_sat_func = ((-1.5957899220e-05 * Wm + 1.4204773829e-03) * L2) +
		         ((4.1688441896e-04 * Wm + -3.9454253278e-02) * Lm) +
		         (-2.7125029084e-03 * Wm + -2.2052642206e-01);
	end
endfunction

analog function real kappa_lin_func;
	input Lm, Wm;
	real Lm, Wm;
	real L2;
	begin
		L2 = Lm*Lm;
		kappa_lin_func = ((1.4996358594e-04 * Wm + -1.6659650260e-02) * L2) +
		         ((-3.0552885825e-03 * Wm + 3.9209809672e-01) * Lm) +
		         (1.6502416341e-02 * Wm + -8.3430386723e+00);
	end
endfunction

analog function real kappa_sat_func;
	input Lm, Wm;
	real Lm, Wm;
	real L2;
	begin
		L2 = Lm*Lm;
		kappa_sat_func = ((-8.8200413721e-05 * Wm + 2.1762620020e-03) * L2) +
		         ((2.3836261626e-03 * Wm + 2.7129416182e-02) * Lm) +
		         (-1.3284608542e-02 * Wm + -6.8660525633e+00);
	end
endfunction

analog function real G0_lin_func;
	input Lm, Wm;
	real Lm, Wm;
	real L2;
	begin
		L2 = Lm*Lm;
		G0_lin_func = ((-2.8373403802e-08 * Wm + 3.3940216788e-06) * L2) +
		         ((6.1749697666e-07 * Wm + -7.2528509891e-05) * Lm) +
		         (-3.1456118614e-06 * Wm + 4.6170813028e-04);
	end
endfunction

analog function real G0_sat_func;
	input Lm, Wm;
	real Lm, Wm;
	real L2;
	begin
		L2 = Lm*Lm;
		G0_sat_func = ((-2.6555300794e-09 * Wm + 4.0639207897e-07) * L2) +
		         ((7.0124149294e-08 * Wm + -1.2798898999e-05) * Lm) +
		         (-4.7825695377e-07 * Wm + 1.3145980754e-04);
	end
endfunction

analog function real Ioff_lin_func;
	input Lm, Wm;
	real Lm, Wm;
	real L2;
	begin
		L2 = Lm*Lm;
		Ioff_lin_func = ((-6.5934086957e-17 * Wm + -6.5582434783e-15) * L2) +
		         ((1.4718725217e-15 * Wm + 1.8640266087e-13) * Lm) +
		         (-5.5694217391e-15 * Wm + 2.2513091304e-12);
	end
endfunction

analog function real Ioff_sat_func;
	input Lm, Wm;
	real Lm, Wm;
	real L2;
	begin
		L2 = Lm*Lm;
		Ioff_sat_func = ((-1.1188382609e-16 * Wm + 1.5290086957e-14) * L2) +
		         ((3.1072459130e-15 * Wm + -4.7521384348e-13) * Lm) +
		         (-2.0034791304e-14 * Wm + 6.5058843478e-12);
	end
endfunction

analog function real DeltaL_func;
	input Wm;
	real Wm;
	begin
		DeltaL_func = -4.3974686957e-03 * Wm + -2.3992034783e-01; // [um]
	end
endfunction

analog function real RSD_func;
	input Wm;
	real Wm;
	begin
		RSD_func = -2.6395073913e-02 * Wm + 3.3593730435e+00; // [kOhm]
	end
endfunction

analog begin

	Vgs = V(g, s);
	Vds = V(d, s);
	Vgd = V(g, d);

	DeltaL = DeltaL_func(W);
	RSD = RSD_func(W) * 1e3; // kOhm -> Ohm
	if (RSD < 0) RSD = 0;

	Von_lin = von_lin_func(L, W);
	Von_sat = von_sat_func(L, W);
	alpha_lin = alpha_lin_func(L, W);
	alpha_sat = alpha_sat_func(L, W);
	k_lin = kappa_lin_func(L, W);
	k_sat = kappa_sat_func(L, W);
	G0_lin = G0_lin_func(L, W);
	G0_sat = G0_sat_func(L, W);
	Ioff_lin = Ioff_lin_func(L, W);
	Ioff_sat = Ioff_sat_func(L, W);

	Lp = L - DeltaL;

	Lov = L*10e-5;
	Lovch = 0.8*L*1e-6;

	Covs = eps_ox * W * 1e-5 * Lov / tox;
	Covd = eps_ox * W * 1e-5 * Lov / tox;
	CCH = eps_ox * W * 1e-5 * Lovch / tox;

	Qovs = Covs * V(g,s);
	Qovd = Covd * V(g,d);
	Qch = CCH * V(g,s);

	if (Von_lin < Von_sat)
		Von_eff = Von_sat;
	else
		Von_eff = Von_lin;

	if (Vgs <= Von_eff) begin
		if (Vds < (Vgs - Von_eff)) begin
			Ids_total = Ioff_lin;
		end
		else begin
			Ids_total = Ioff_sat;
		end
	end
	else begin
		term_exp = exp(k_lin * (Vgs - Von_eff)**alpha_lin);
		G = G0_lin * (W / Lp) * term_exp;
		Ids_lin = (G * Vds + Ioff_lin) / (1 + RSD * G);

		Ids_sat = G0_sat * (W/Lp) * exp(k_sat * (Vgs - Von_eff)**alpha_sat) * (Vgs - Von_eff) + Ioff_sat;

		Ids_total = (Ids_lin**(-m) + Ids_sat**(-m))**(-1/m);
	end

	I(d,s) <+ Ids_total;
	I(g,s) <+ ddt(Qovs + Qch);
	I(g,d) <+ ddt(Qovd);
end

endmodule
